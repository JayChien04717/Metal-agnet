# Ansys Electronics Desktop project, version 2021.2
materials:
  vacuum: permittivity=1
  silicon: permittivity=11.9

design chip6_v1_hfss (HFSS, DrivenModal, model units mm)
variables:
  Lj = 10nH
  Cj = 0fF
geometry:
  lead_a_cin_path = polyline((-0.003980499, 0, 0) (-0.0040325, 0, 0))
  lead_a_cin = polyline((-0.003980499, -5e-06, 0) (-0.003980499, 5e-06, 0))
  lead_a_cin.sweep_along_path(lead_a_cin_path)
  lead_a_sub_cin_path = polyline((-0.003980499, 0, 0) (-0.0040325, 0, 0))
  lead_a_sub_cin = polyline((-0.003980499, -1.1e-05, 0) (-0.003980499, 1.1e-05, 0))
  lead_a_sub_cin.sweep_along_path(lead_a_sub_cin_path)
  lead_b_cin_path = polyline((-0.003879501, 0, 0) (-0.0037675, 0, 0))
  lead_b_cin = polyline((-0.003879501, 5e-06, 0) (-0.003879501, -5e-06, 0))
  lead_b_cin.sweep_along_path(lead_b_cin_path)
  lead_b_sub_cin_path = polyline((-0.003879501, 0, 0) (-0.0037675, 0, 0))
  lead_b_sub_cin = polyline((-0.003879501, 1.1e-05, 0) (-0.003879501, -1.1e-05, 0))
  lead_b_sub_cin.sweep_along_path(lead_b_sub_cin_path)
  lead_a_cp_ch2_path = polyline((-0.0032, -0.000362999, 0) (-0.0032, -0.000415, 0))
  lead_a_cp_ch2 = polyline((-0.003195, -0.000362999, 0) (-0.003205, -0.000362999, 0))
  lead_a_cp_ch2.sweep_along_path(lead_a_cp_ch2_path)
  lead_a_sub_cp_ch2_path = polyline((-0.0032, -0.000362999, 0) (-0.0032, -0.000415, 0))
  lead_a_sub_cp_ch2 = polyline((-0.003189, -0.000362999, 0) (-0.003211, -0.000362999, 0))
  lead_a_sub_cp_ch2.sweep_along_path(lead_a_sub_cp_ch2_path)
  lead_b_cp_ch2_path = polyline((-0.0032, -0.000262001, 0) (-0.0032, -0.00015, 0))
  lead_b_cp_ch2 = polyline((-0.003205, -0.000262001, 0) (-0.003195, -0.000262001, 0))
  lead_b_cp_ch2.sweep_along_path(lead_b_cp_ch2_path)
  lead_b_sub_cp_ch2_path = polyline((-0.0032, -0.000262001, 0) (-0.0032, -0.00015, 0))
  lead_b_sub_cp_ch2 = polyline((-0.003211, -0.000262001, 0) (-0.003189, -0.000262001, 0))
  lead_b_sub_cp_ch2.sweep_along_path(lead_b_sub_cp_ch2_path)
  trace_stub_p_ch2_path = polyline((-0.0032, -0.0001, 0) (-0.0032, -0.00015, 0))
  trace_stub_p_ch2 = polyline((-0.003195, -0.0001, 0) (-0.003205, -0.0001, 0))
  trace_stub_p_ch2.sweep_along_path(trace_stub_p_ch2_path)
  cut_stub_p_ch2_path = polyline((-0.0032, -0.0001, 0) (-0.0032, -0.00015, 0))
  cut_stub_p_ch2 = polyline((-0.003189, -0.0001, 0) (-0.003211, -0.0001, 0))
  cut_stub_p_ch2.sweep_along_path(cut_stub_p_ch2_path)
  trace_feed_jf_ch2_path = polyline((-0.0032, -0.000415, 0) (-0.0032, -0.001465, 0))
  trace_feed_jf_ch2 = polyline((-0.003195, -0.000415, 0) (-0.003205, -0.000415, 0))
  trace_feed_jf_ch2.sweep_along_path(trace_feed_jf_ch2_path)
  cut_feed_jf_ch2_path = polyline((-0.0032, -0.000415, 0) (-0.0032, -0.001465, 0))
  cut_feed_jf_ch2 = polyline((-0.003189, -0.000415, 0) (-0.003211, -0.000415, 0))
  cut_feed_jf_ch2.sweep_along_path(cut_feed_jf_ch2_path)
  lead_a_cj_ch2_path = polyline((-0.003134499, -0.001615, 0) (-0.0031445, -0.001615, 0))
  lead_a_cj_ch2 = polyline((-0.003134499, -0.00162, 0) (-0.003134499, -0.00161, 0))
  lead_a_cj_ch2.sweep_along_path(lead_a_cj_ch2_path)
  lead_a_sub_cj_ch2_path = polyline((-0.003134499, -0.001615, 0) (-0.0031445, -0.001615, 0))
  lead_a_sub_cj_ch2 = polyline((-0.003134499, -0.001626, 0) (-0.003134499, -0.001604, 0))
  lead_a_sub_cj_ch2.sweep_along_path(lead_a_sub_cj_ch2_path)
  lead_b_cj_ch2_path = polyline((-0.003065501, -0.001615, 0) (-0.0030555, -0.001615, 0))
  lead_b_cj_ch2 = polyline((-0.003065501, -0.00161, 0) (-0.003065501, -0.00162, 0))
  lead_b_cj_ch2.sweep_along_path(lead_b_cj_ch2_path)
  lead_b_sub_cj_ch2_path = polyline((-0.003065501, -0.001615, 0) (-0.0030555, -0.001615, 0))
  lead_b_sub_cj_ch2 = polyline((-0.003065501, -0.001604, 0) (-0.003065501, -0.001626, 0))
  lead_b_sub_cj_ch2.sweep_along_path(lead_b_sub_cj_ch2_path)
  trace_stub_f_ch2_path = polyline((-0.0031645, -0.001615, 0) (-0.0031445, -0.001615, 0))
  trace_stub_f_ch2 = polyline((-0.0031645, -0.00161, 0) (-0.0031645, -0.00162, 0))
  trace_stub_f_ch2.sweep_along_path(trace_stub_f_ch2_path)
  cut_stub_f_ch2_path = polyline((-0.0031645, -0.001615, 0) (-0.0031445, -0.001615, 0))
  cut_stub_f_ch2 = polyline((-0.0031645, -0.001604, 0) (-0.0031645, -0.001626, 0))
  cut_stub_f_ch2.sweep_along_path(cut_stub_f_ch2_path)
  trace_stub_r_ch2_path = polyline((-0.0030355, -0.001615, 0) (-0.0030555, -0.001615, 0))
  trace_stub_r_ch2 = polyline((-0.0030355, -0.00162, 0) (-0.0030355, -0.00161, 0))
  trace_stub_r_ch2.sweep_along_path(trace_stub_r_ch2_path)
  cut_stub_r_ch2_path = polyline((-0.0030355, -0.001615, 0) (-0.0030555, -0.001615, 0))
  cut_stub_r_ch2 = polyline((-0.0030355, -0.001626, 0) (-0.0030355, -0.001604, 0))
  cut_stub_r_ch2.sweep_along_path(cut_stub_r_ch2_path)
  trace_filt_ch2_path = polyline(z=0, xy: (-0.00375, -0.002045) (-0.00375, -0.0028311891) (-0.0035, -0.0028311891) (-0.0035, -0.002045) (-0.0032, -0.002045) (-0.0032, -0.001765))
  trace_filt_ch2_path.fillet(Vertices=trace_filt_ch2_path.vertex(2 of 6, 3 of 6, 4 of 6, 5 of 6) Radius=9.9e-05 Setback=0mm)
  trace_filt_ch2 = polyline((-0.003745, -0.002045, 0) (-0.003755, -0.002045, 0))
  trace_filt_ch2.sweep_along_path(trace_filt_ch2_path)
  cut_filt_ch2_path = polyline(z=0, xy: (-0.00375, -0.002045) (-0.00375, -0.0028311891) (-0.0035, -0.0028311891) (-0.0035, -0.002045) (-0.0032, -0.002045) (-0.0032, -0.001765))
  cut_filt_ch2_path.fillet(Vertices=cut_filt_ch2_path.vertex(2 of 6, 3 of 6, 4 of 6, 5 of 6) Radius=9.9e-05 Setback=0mm)
  cut_filt_ch2 = polyline((-0.003739, -0.002045, 0) (-0.003761, -0.002045, 0))
  cut_filt_ch2.sweep_along_path(cut_filt_ch2_path)
  trace_res_a_ch2_path = polyline((-0.003, -0.002915, 0) (-0.003, -0.001765, 0))
  trace_res_a_ch2 = polyline((-0.003005, -0.002915, 0) (-0.002995, -0.002915, 0))
  trace_res_a_ch2.sweep_along_path(trace_res_a_ch2_path)
  cut_res_a_ch2_path = polyline((-0.003, -0.002915, 0) (-0.003, -0.001765, 0))
  cut_res_a_ch2 = polyline((-0.003011, -0.002915, 0) (-0.002989, -0.002915, 0))
  cut_res_a_ch2.sweep_along_path(cut_res_a_ch2_path)
  trace_res_ch2_path = polyline(z=0, xy: (-0.00225, -0.000855) (-0.00225, -0.0018045571) (-0.0026, -0.0018045571) (-0.0026, -0.000855) (-0.003, -0.000855) (-0.003, -0.001465))
  trace_res_ch2_path.fillet(Vertices=trace_res_ch2_path.vertex(2 of 6, 3 of 6, 4 of 6, 5 of 6) Radius=9.9e-05 Setback=0mm)
  trace_res_ch2 = polyline((-0.002245, -0.000855, 0) (-0.002255, -0.000855, 0))
  trace_res_ch2.sweep_along_path(trace_res_ch2_path)
  cut_res_ch2_path = polyline(z=0, xy: (-0.00225, -0.000855) (-0.00225, -0.0018045571) (-0.0026, -0.0018045571) (-0.0026, -0.000855) (-0.003, -0.000855) (-0.003, -0.001465))
  cut_res_ch2_path.fillet(Vertices=cut_res_ch2_path.vertex(2 of 6, 3 of 6, 4 of 6, 5 of 6) Radius=9.9e-05 Setback=0mm)
  cut_res_ch2 = polyline((-0.002239, -0.000855, 0) (-0.002261, -0.000855, 0))
  cut_res_ch2.sweep_along_path(cut_res_ch2_path)
  lead_a_cp_ch4_path = polyline((-0.0019, 0.000362999, 0) (-0.0019, 0.000415, 0))
  lead_a_cp_ch4 = polyline((-0.001905, 0.000362999, 0) (-0.001895, 0.000362999, 0))
  lead_a_cp_ch4.sweep_along_path(lead_a_cp_ch4_path)
  lead_a_sub_cp_ch4_path = polyline((-0.0019, 0.000362999, 0) (-0.0019, 0.000415, 0))
  lead_a_sub_cp_ch4 = polyline((-0.001911, 0.000362999, 0) (-0.001889, 0.000362999, 0))
  lead_a_sub_cp_ch4.sweep_along_path(lead_a_sub_cp_ch4_path)
  lead_b_cp_ch4_path = polyline((-0.0019, 0.000262001, 0) (-0.0019, 0.00015, 0))
  lead_b_cp_ch4 = polyline((-0.001895, 0.000262001, 0) (-0.001905, 0.000262001, 0))
  lead_b_cp_ch4.sweep_along_path(lead_b_cp_ch4_path)
  lead_b_sub_cp_ch4_path = polyline((-0.0019, 0.000262001, 0) (-0.0019, 0.00015, 0))
  lead_b_sub_cp_ch4 = polyline((-0.001889, 0.000262001, 0) (-0.001911, 0.000262001, 0))
  lead_b_sub_cp_ch4.sweep_along_path(lead_b_sub_cp_ch4_path)
  trace_stub_p_ch4_path = polyline((-0.0019, 0.0001, 0) (-0.0019, 0.00015, 0))
  trace_stub_p_ch4 = polyline((-0.001905, 0.0001, 0) (-0.001895, 0.0001, 0))
  trace_stub_p_ch4.sweep_along_path(trace_stub_p_ch4_path)
  cut_stub_p_ch4_path = polyline((-0.0019, 0.0001, 0) (-0.0019, 0.00015, 0))
  cut_stub_p_ch4 = polyline((-0.001911, 0.0001, 0) (-0.001889, 0.0001, 0))
  cut_stub_p_ch4.sweep_along_path(cut_stub_p_ch4_path)
  trace_feed_jf_ch4_path = polyline((-0.0019, 0.000415, 0) (-0.0019, 0.001465, 0))
  trace_feed_jf_ch4 = polyline((-0.001905, 0.000415, 0) (-0.001895, 0.000415, 0))
  trace_feed_jf_ch4.sweep_along_path(trace_feed_jf_ch4_path)
  cut_feed_jf_ch4_path = polyline((-0.0019, 0.000415, 0) (-0.0019, 0.001465, 0))
  cut_feed_jf_ch4 = polyline((-0.001911, 0.000415, 0) (-0.001889, 0.000415, 0))
  cut_feed_jf_ch4.sweep_along_path(cut_feed_jf_ch4_path)
  lead_a_cj_ch4_path = polyline((-0.001834499, 0.001615, 0) (-0.0018445, 0.001615, 0))
  lead_a_cj_ch4 = polyline((-0.001834499, 0.00161, 0) (-0.001834499, 0.00162, 0))
  lead_a_cj_ch4.sweep_along_path(lead_a_cj_ch4_path)
  lead_a_sub_cj_ch4_path = polyline((-0.001834499, 0.001615, 0) (-0.0018445, 0.001615, 0))
  lead_a_sub_cj_ch4 = polyline((-0.001834499, 0.001604, 0) (-0.001834499, 0.001626, 0))
  lead_a_sub_cj_ch4.sweep_along_path(lead_a_sub_cj_ch4_path)
  lead_b_cj_ch4_path = polyline((-0.001765501, 0.001615, 0) (-0.0017555, 0.001615, 0))
  lead_b_cj_ch4 = polyline((-0.001765501, 0.00162, 0) (-0.001765501, 0.00161, 0))
  lead_b_cj_ch4.sweep_along_path(lead_b_cj_ch4_path)
  lead_b_sub_cj_ch4_path = polyline((-0.001765501, 0.001615, 0) (-0.0017555, 0.001615, 0))
  lead_b_sub_cj_ch4 = polyline((-0.001765501, 0.001626, 0) (-0.001765501, 0.001604, 0))
  lead_b_sub_cj_ch4.sweep_along_path(lead_b_sub_cj_ch4_path)
  trace_stub_f_ch4_path = polyline((-0.0018645, 0.001615, 0) (-0.0018445, 0.001615, 0))
  trace_stub_f_ch4 = polyline((-0.0018645, 0.00162, 0) (-0.0018645, 0.00161, 0))
  trace_stub_f_ch4.sweep_along_path(trace_stub_f_ch4_path)
  cut_stub_f_ch4_path = polyline((-0.0018645, 0.001615, 0) (-0.0018445, 0.001615, 0))
  cut_stub_f_ch4 = polyline((-0.0018645, 0.001626, 0) (-0.0018645, 0.001604, 0))
  cut_stub_f_ch4.sweep_along_path(cut_stub_f_ch4_path)
  trace_stub_r_ch4_path = polyline((-0.0017355, 0.001615, 0) (-0.0017555, 0.001615, 0))
  trace_stub_r_ch4 = polyline((-0.0017355, 0.00161, 0) (-0.0017355, 0.00162, 0))
  trace_stub_r_ch4.sweep_along_path(trace_stub_r_ch4_path)
  cut_stub_r_ch4_path = polyline((-0.0017355, 0.001615, 0) (-0.0017555, 0.001615, 0))
  cut_stub_r_ch4 = polyline((-0.0017355, 0.001604, 0) (-0.0017355, 0.001626, 0))
  cut_stub_r_ch4.sweep_along_path(cut_stub_r_ch4_path)
  trace_filt_ch4_path = polyline(z=0, xy: (-0.00245, 0.002045) (-0.00245, 0.0027022778) (-0.0022, 0.0027022778) (-0.0022, 0.002045) (-0.0019, 0.002045) (-0.0019, 0.001765))
  trace_filt_ch4_path.fillet(Vertices=trace_filt_ch4_path.vertex(2 of 6, 3 of 6, 4 of 6, 5 of 6) Radius=9.9e-05 Setback=0mm)
  trace_filt_ch4 = polyline((-0.002455, 0.002045, 0) (-0.002445, 0.002045, 0))
  trace_filt_ch4.sweep_along_path(trace_filt_ch4_path)
  cut_filt_ch4_path = polyline(z=0, xy: (-0.00245, 0.002045) (-0.00245, 0.0027022778) (-0.0022, 0.0027022778) (-0.0022, 0.002045) (-0.0019, 0.002045) (-0.0019, 0.001765))
  cut_filt_ch4_path.fillet(Vertices=cut_filt_ch4_path.vertex(2 of 6, 3 of 6, 4 of 6, 5 of 6) Radius=9.9e-05 Setback=0mm)
  cut_filt_ch4 = polyline((-0.002461, 0.002045, 0) (-0.002439, 0.002045, 0))
  cut_filt_ch4.sweep_along_path(cut_filt_ch4_path)
  trace_res_a_ch4_path = polyline((-0.0017, 0.002915, 0) (-0.0017, 0.001765, 0))
  trace_res_a_ch4 = polyline((-0.001695, 0.002915, 0) (-0.001705, 0.002915, 0))
  trace_res_a_ch4.sweep_along_path(trace_res_a_ch4_path)
  cut_res_a_ch4_path = polyline((-0.0017, 0.002915, 0) (-0.0017, 0.001765, 0))
  cut_res_a_ch4 = polyline((-0.001689, 0.002915, 0) (-0.001711, 0.002915, 0))
  cut_res_a_ch4.sweep_along_path(cut_res_a_ch4_path)
  trace_res_ch4_path = polyline(z=0, xy: (-0.00095, 0.000855) (-0.00095, 0.0016717786) (-0.0013, 0.0016717786) (-0.0013, 0.000855) (-0.0017, 0.000855) (-0.0017, 0.001465))
  trace_res_ch4_path.fillet(Vertices=trace_res_ch4_path.vertex(2 of 6, 3 of 6, 4 of 6, 5 of 6) Radius=9.9e-05 Setback=0mm)
  trace_res_ch4 = polyline((-0.000955, 0.000855, 0) (-0.000945, 0.000855, 0))
  trace_res_ch4.sweep_along_path(trace_res_ch4_path)
  cut_res_ch4_path = polyline(z=0, xy: (-0.00095, 0.000855) (-0.00095, 0.0016717786) (-0.0013, 0.0016717786) (-0.0013, 0.000855) (-0.0017, 0.000855) (-0.0017, 0.001465))
  cut_res_ch4_path.fillet(Vertices=cut_res_ch4_path.vertex(2 of 6, 3 of 6, 4 of 6, 5 of 6) Radius=9.9e-05 Setback=0mm)
  cut_res_ch4 = polyline((-0.000961, 0.000855, 0) (-0.000939, 0.000855, 0))
  cut_res_ch4.sweep_along_path(cut_res_ch4_path)
  lead_a_cp_ch6_path = polyline((-0.0006, -0.000362999, 0) (-0.0006, -0.000415, 0))
  lead_a_cp_ch6 = polyline((-0.000595, -0.000362999, 0) (-0.000605, -0.000362999, 0))
  lead_a_cp_ch6.sweep_along_path(lead_a_cp_ch6_path)
  lead_a_sub_cp_ch6_path = polyline((-0.0006, -0.000362999, 0) (-0.0006, -0.000415, 0))
  lead_a_sub_cp_ch6 = polyline((-0.000589, -0.000362999, 0) (-0.000611, -0.000362999, 0))
  lead_a_sub_cp_ch6.sweep_along_path(lead_a_sub_cp_ch6_path)
  lead_b_cp_ch6_path = polyline((-0.0006, -0.000262001, 0) (-0.0006, -0.00015, 0))
  lead_b_cp_ch6 = polyline((-0.000605, -0.000262001, 0) (-0.000595, -0.000262001, 0))
  lead_b_cp_ch6.sweep_along_path(lead_b_cp_ch6_path)
  lead_b_sub_cp_ch6_path = polyline((-0.0006, -0.000262001, 0) (-0.0006, -0.00015, 0))
  lead_b_sub_cp_ch6 = polyline((-0.000611, -0.000262001, 0) (-0.000589, -0.000262001, 0))
  lead_b_sub_cp_ch6.sweep_along_path(lead_b_sub_cp_ch6_path)
  trace_stub_p_ch6_path = polyline((-0.0006, -0.0001, 0) (-0.0006, -0.00015, 0))
  trace_stub_p_ch6 = polyline((-0.000595, -0.0001, 0) (-0.000605, -0.0001, 0))
  trace_stub_p_ch6.sweep_along_path(trace_stub_p_ch6_path)
  cut_stub_p_ch6_path = polyline((-0.0006, -0.0001, 0) (-0.0006, -0.00015, 0))
  cut_stub_p_ch6 = polyline((-0.000589, -0.0001, 0) (-0.000611, -0.0001, 0))
  cut_stub_p_ch6.sweep_along_path(cut_stub_p_ch6_path)
  trace_feed_jf_ch6_path = polyline((-0.0006, -0.000415, 0) (-0.0006, -0.001465, 0))
  trace_feed_jf_ch6 = polyline((-0.000595, -0.000415, 0) (-0.000605, -0.000415, 0))
  trace_feed_jf_ch6.sweep_along_path(trace_feed_jf_ch6_path)
  cut_feed_jf_ch6_path = polyline((-0.0006, -0.000415, 0) (-0.0006, -0.001465, 0))
  cut_feed_jf_ch6 = polyline((-0.000589, -0.000415, 0) (-0.000611, -0.000415, 0))
  cut_feed_jf_ch6.sweep_along_path(cut_feed_jf_ch6_path)
  lead_a_cj_ch6_path = polyline((-0.000534499, -0.001615, 0) (-0.0005445, -0.001615, 0))
  lead_a_cj_ch6 = polyline((-0.000534499, -0.00162, 0) (-0.000534499, -0.00161, 0))
  lead_a_cj_ch6.sweep_along_path(lead_a_cj_ch6_path)
  lead_a_sub_cj_ch6_path = polyline((-0.000534499, -0.001615, 0) (-0.0005445, -0.001615, 0))
  lead_a_sub_cj_ch6 = polyline((-0.000534499, -0.001626, 0) (-0.000534499, -0.001604, 0))
  lead_a_sub_cj_ch6.sweep_along_path(lead_a_sub_cj_ch6_path)
  lead_b_cj_ch6_path = polyline((-0.000465501, -0.001615, 0) (-0.0004555, -0.001615, 0))
  lead_b_cj_ch6 = polyline((-0.000465501, -0.00161, 0) (-0.000465501, -0.00162, 0))
  lead_b_cj_ch6.sweep_along_path(lead_b_cj_ch6_path)
  lead_b_sub_cj_ch6_path = polyline((-0.000465501, -0.001615, 0) (-0.0004555, -0.001615, 0))
  lead_b_sub_cj_ch6 = polyline((-0.000465501, -0.001604, 0) (-0.000465501, -0.001626, 0))
  lead_b_sub_cj_ch6.sweep_along_path(lead_b_sub_cj_ch6_path)
  trace_stub_f_ch6_path = polyline((-0.0005645, -0.001615, 0) (-0.0005445, -0.001615, 0))
  trace_stub_f_ch6 = polyline((-0.0005645, -0.00161, 0) (-0.0005645, -0.00162, 0))
  trace_stub_f_ch6.sweep_along_path(trace_stub_f_ch6_path)
  cut_stub_f_ch6_path = polyline((-0.0005645, -0.001615, 0) (-0.0005445, -0.001615, 0))
  cut_stub_f_ch6 = polyline((-0.0005645, -0.001604, 0) (-0.0005645, -0.001626, 0))
  cut_stub_f_ch6.sweep_along_path(cut_stub_f_ch6_path)
  trace_stub_r_ch6_path = polyline((-0.0004355, -0.001615, 0) (-0.0004555, -0.001615, 0))
  trace_stub_r_ch6 = polyline((-0.0004355, -0.00162, 0) (-0.0004355, -0.00161, 0))
  trace_stub_r_ch6.sweep_along_path(trace_stub_r_ch6_path)
  cut_stub_r_ch6_path = polyline((-0.0004355, -0.001615, 0) (-0.0004555, -0.001615, 0))
  cut_stub_r_ch6 = polyline((-0.0004355, -0.001626, 0) (-0.0004355, -0.001604, 0))
  cut_stub_r_ch6.sweep_along_path(cut_stub_r_ch6_path)
  trace_filt_ch6_path = polyline(z=0, xy: (-0.00115, -0.002045) (-0.00115, -0.0025879963) (-0.0009, -0.0025879963) (-0.0009, -0.002045) (-0.0006, -0.002045) (-0.0006, -0.001765))
  trace_filt_ch6_path.fillet(Vertices=trace_filt_ch6_path.vertex(2 of 6, 3 of 6, 4 of 6, 5 of 6) Radius=9.9e-05 Setback=0mm)
  trace_filt_ch6 = polyline((-0.001145, -0.002045, 0) (-0.001155, -0.002045, 0))
  trace_filt_ch6.sweep_along_path(trace_filt_ch6_path)
  cut_filt_ch6_path = polyline(z=0, xy: (-0.00115, -0.002045) (-0.00115, -0.0025879963) (-0.0009, -0.0025879963) (-0.0009, -0.002045) (-0.0006, -0.002045) (-0.0006, -0.001765))
  cut_filt_ch6_path.fillet(Vertices=cut_filt_ch6_path.vertex(2 of 6, 3 of 6, 4 of 6, 5 of 6) Radius=9.9e-05 Setback=0mm)
  cut_filt_ch6 = polyline((-0.001139, -0.002045, 0) (-0.001161, -0.002045, 0))
  cut_filt_ch6.sweep_along_path(cut_filt_ch6_path)
  trace_res_a_ch6_path = polyline((-0.0004, -0.002915, 0) (-0.0004, -0.001765, 0))
  trace_res_a_ch6 = polyline((-0.000405, -0.002915, 0) (-0.000395, -0.002915, 0))
  trace_res_a_ch6.sweep_along_path(trace_res_a_ch6_path)
  cut_res_a_ch6_path = polyline((-0.0004, -0.002915, 0) (-0.0004, -0.001765, 0))
  cut_res_a_ch6 = polyline((-0.000411, -0.002915, 0) (-0.000389, -0.002915, 0))
  cut_res_a_ch6.sweep_along_path(cut_res_a_ch6_path)
  trace_res_ch6_path = polyline(z=0, xy: (0.00035, -0.000855) (0.00035, -0.0015537219) (0, -0.0015537219) (0, -0.000855) (-0.0004, -0.000855) (-0.0004, -0.001465))
  trace_res_ch6_path.fillet(Vertices=trace_res_ch6_path.vertex(2 of 6, 3 of 6, 4 of 6, 5 of 6) Radius=9.9e-05 Setback=0mm)
  trace_res_ch6 = polyline((0.000355, -0.000855, 0) (0.000345, -0.000855, 0))
  trace_res_ch6.sweep_along_path(trace_res_ch6_path)
  cut_res_ch6_path = polyline(z=0, xy: (0.00035, -0.000855) (0.00035, -0.0015537219) (0, -0.0015537219) (0, -0.000855) (-0.0004, -0.000855) (-0.0004, -0.001465))
  cut_res_ch6_path.fillet(Vertices=cut_res_ch6_path.vertex(2 of 6, 3 of 6, 4 of 6, 5 of 6) Radius=9.9e-05 Setback=0mm)
  cut_res_ch6 = polyline((0.000361, -0.000855, 0) (0.000339, -0.000855, 0))
  cut_res_ch6.sweep_along_path(cut_res_ch6_path)
  lead_a_cp_ch1_path = polyline((0.0007, 0.000362999, 0) (0.0007, 0.000415, 0))
  lead_a_cp_ch1 = polyline((0.000695, 0.000362999, 0) (0.000705, 0.000362999, 0))
  lead_a_cp_ch1.sweep_along_path(lead_a_cp_ch1_path)
  lead_a_sub_cp_ch1_path = polyline((0.0007, 0.000362999, 0) (0.0007, 0.000415, 0))
  lead_a_sub_cp_ch1 = polyline((0.000689, 0.000362999, 0) (0.000711, 0.000362999, 0))
  lead_a_sub_cp_ch1.sweep_along_path(lead_a_sub_cp_ch1_path)
  lead_b_cp_ch1_path = polyline((0.0007, 0.000262001, 0) (0.0007, 0.00015, 0))
  lead_b_cp_ch1 = polyline((0.000705, 0.000262001, 0) (0.000695, 0.000262001, 0))
  lead_b_cp_ch1.sweep_along_path(lead_b_cp_ch1_path)
  lead_b_sub_cp_ch1_path = polyline((0.0007, 0.000262001, 0) (0.0007, 0.00015, 0))
  lead_b_sub_cp_ch1 = polyline((0.000711, 0.000262001, 0) (0.000689, 0.000262001, 0))
  lead_b_sub_cp_ch1.sweep_along_path(lead_b_sub_cp_ch1_path)
  trace_stub_p_ch1_path = polyline((0.0007, 0.0001, 0) (0.0007, 0.00015, 0))
  trace_stub_p_ch1 = polyline((0.000695, 0.0001, 0) (0.000705, 0.0001, 0))
  trace_stub_p_ch1.sweep_along_path(trace_stub_p_ch1_path)
  cut_stub_p_ch1_path = polyline((0.0007, 0.0001, 0) (0.0007, 0.00015, 0))
  cut_stub_p_ch1 = polyline((0.000689, 0.0001, 0) (0.000711, 0.0001, 0))
  cut_stub_p_ch1.sweep_along_path(cut_stub_p_ch1_path)
  trace_feed_jf_ch1_path = polyline((0.0007, 0.000415, 0) (0.0007, 0.001465, 0))
  trace_feed_jf_ch1 = polyline((0.000695, 0.000415, 0) (0.000705, 0.000415, 0))
  trace_feed_jf_ch1.sweep_along_path(trace_feed_jf_ch1_path)
  cut_feed_jf_ch1_path = polyline((0.0007, 0.000415, 0) (0.0007, 0.001465, 0))
  cut_feed_jf_ch1 = polyline((0.000689, 0.000415, 0) (0.000711, 0.000415, 0))
  cut_feed_jf_ch1.sweep_along_path(cut_feed_jf_ch1_path)
  lead_a_cj_ch1_path = polyline((0.000765501, 0.001615, 0) (0.0007555, 0.001615, 0))
  lead_a_cj_ch1 = polyline((0.000765501, 0.00161, 0) (0.000765501, 0.00162, 0))
  lead_a_cj_ch1.sweep_along_path(lead_a_cj_ch1_path)
  lead_a_sub_cj_ch1_path = polyline((0.000765501, 0.001615, 0) (0.0007555, 0.001615, 0))
  lead_a_sub_cj_ch1 = polyline((0.000765501, 0.001604, 0) (0.000765501, 0.001626, 0))
  lead_a_sub_cj_ch1.sweep_along_path(lead_a_sub_cj_ch1_path)
  lead_b_cj_ch1_path = polyline((0.000834499, 0.001615, 0) (0.0008445, 0.001615, 0))
  lead_b_cj_ch1 = polyline((0.000834499, 0.00162, 0) (0.000834499, 0.00161, 0))
  lead_b_cj_ch1.sweep_along_path(lead_b_cj_ch1_path)
  lead_b_sub_cj_ch1_path = polyline((0.000834499, 0.001615, 0) (0.0008445, 0.001615, 0))
  lead_b_sub_cj_ch1 = polyline((0.000834499, 0.001626, 0) (0.000834499, 0.001604, 0))
  lead_b_sub_cj_ch1.sweep_along_path(lead_b_sub_cj_ch1_path)
  trace_stub_f_ch1_path = polyline((0.0007355, 0.001615, 0) (0.0007555, 0.001615, 0))
  trace_stub_f_ch1 = polyline((0.0007355, 0.00162, 0) (0.0007355, 0.00161, 0))
  trace_stub_f_ch1.sweep_along_path(trace_stub_f_ch1_path)
  cut_stub_f_ch1_path = polyline((0.0007355, 0.001615, 0) (0.0007555, 0.001615, 0))
  cut_stub_f_ch1 = polyline((0.0007355, 0.001626, 0) (0.0007355, 0.001604, 0))
  cut_stub_f_ch1.sweep_along_path(cut_stub_f_ch1_path)
  trace_stub_r_ch1_path = polyline((0.0008645, 0.001615, 0) (0.0008445, 0.001615, 0))
  trace_stub_r_ch1 = polyline((0.0008645, 0.00161, 0) (0.0008645, 0.00162, 0))
  trace_stub_r_ch1.sweep_along_path(trace_stub_r_ch1_path)
  cut_stub_r_ch1_path = polyline((0.0008645, 0.001615, 0) (0.0008445, 0.001615, 0))
  cut_stub_r_ch1 = polyline((0.0008645, 0.001604, 0) (0.0008645, 0.001626, 0))
  cut_stub_r_ch1.sweep_along_path(cut_stub_r_ch1_path)
  trace_filt_ch1_path = polyline(z=0, xy: (0.00015, 0.002045) (0.00015, 0.0029020014) (0.0004, 0.0029020014) (0.0004, 0.002045) (0.0007, 0.002045) (0.0007, 0.001765))
  trace_filt_ch1_path.fillet(Vertices=trace_filt_ch1_path.vertex(2 of 6, 3 of 6, 4 of 6, 5 of 6) Radius=9.9e-05 Setback=0mm)
  trace_filt_ch1 = polyline((0.000145, 0.002045, 0) (0.000155, 0.002045, 0))
  trace_filt_ch1.sweep_along_path(trace_filt_ch1_path)
  cut_filt_ch1_path = polyline(z=0, xy: (0.00015, 0.002045) (0.00015, 0.0029020014) (0.0004, 0.0029020014) (0.0004, 0.002045) (0.0007, 0.002045) (0.0007, 0.001765))
  cut_filt_ch1_path.fillet(Vertices=cut_filt_ch1_path.vertex(2 of 6, 3 of 6, 4 of 6, 5 of 6) Radius=9.9e-05 Setback=0mm)
  cut_filt_ch1 = polyline((0.000139, 0.002045, 0) (0.000161, 0.002045, 0))
  cut_filt_ch1.sweep_along_path(cut_filt_ch1_path)
  trace_res_a_ch1_path = polyline((0.0009, 0.002915, 0) (0.0009, 0.001765, 0))
  trace_res_a_ch1 = polyline((0.000905, 0.002915, 0) (0.000895, 0.002915, 0))
  trace_res_a_ch1.sweep_along_path(trace_res_a_ch1_path)
  cut_res_a_ch1_path = polyline((0.0009, 0.002915, 0) (0.0009, 0.001765, 0))
  cut_res_a_ch1 = polyline((0.000911, 0.002915, 0) (0.000889, 0.002915, 0))
  cut_res_a_ch1.sweep_along_path(cut_res_a_ch1_path)
  trace_res_ch1_path = polyline(z=0, xy: (0.00165, 0.000855) (0.00165, 0.0018773425) (0.0013, 0.0018773425) (0.0013, 0.000855) (0.0009, 0.000855) (0.0009, 0.001465))
  trace_res_ch1_path.fillet(Vertices=trace_res_ch1_path.vertex(2 of 6, 3 of 6, 4 of 6, 5 of 6) Radius=9.9e-05 Setback=0mm)
  trace_res_ch1 = polyline((0.001645, 0.000855, 0) (0.001655, 0.000855, 0))
  trace_res_ch1.sweep_along_path(trace_res_ch1_path)
  cut_res_ch1_path = polyline(z=0, xy: (0.00165, 0.000855) (0.00165, 0.0018773425) (0.0013, 0.0018773425) (0.0013, 0.000855) (0.0009, 0.000855) (0.0009, 0.001465))
  cut_res_ch1_path.fillet(Vertices=cut_res_ch1_path.vertex(2 of 6, 3 of 6, 4 of 6, 5 of 6) Radius=9.9e-05 Setback=0mm)
  cut_res_ch1 = polyline((0.001639, 0.000855, 0) (0.001661, 0.000855, 0))
  cut_res_ch1.sweep_along_path(cut_res_ch1_path)
  lead_a_cp_ch3_path = polyline((0.002, -0.000362999, 0) (0.002, -0.000415, 0))
  lead_a_cp_ch3 = polyline((0.002005, -0.000362999, 0) (0.001995, -0.000362999, 0))
  lead_a_cp_ch3.sweep_along_path(lead_a_cp_ch3_path)
  lead_a_sub_cp_ch3_path = polyline((0.002, -0.000362999, 0) (0.002, -0.000415, 0))
  lead_a_sub_cp_ch3 = polyline((0.002011, -0.000362999, 0) (0.001989, -0.000362999, 0))
  lead_a_sub_cp_ch3.sweep_along_path(lead_a_sub_cp_ch3_path)
  lead_b_cp_ch3_path = polyline((0.002, -0.000262001, 0) (0.002, -0.00015, 0))
  lead_b_cp_ch3 = polyline((0.001995, -0.000262001, 0) (0.002005, -0.000262001, 0))
  lead_b_cp_ch3.sweep_along_path(lead_b_cp_ch3_path)
  lead_b_sub_cp_ch3_path = polyline((0.002, -0.000262001, 0) (0.002, -0.00015, 0))
  lead_b_sub_cp_ch3 = polyline((0.001989, -0.000262001, 0) (0.002011, -0.000262001, 0))
  lead_b_sub_cp_ch3.sweep_along_path(lead_b_sub_cp_ch3_path)
  trace_stub_p_ch3_path = polyline((0.002, -0.0001, 0) (0.002, -0.00015, 0))
  trace_stub_p_ch3 = polyline((0.002005, -0.0001, 0) (0.001995, -0.0001, 0))
  trace_stub_p_ch3.sweep_along_path(trace_stub_p_ch3_path)
  cut_stub_p_ch3_path = polyline((0.002, -0.0001, 0) (0.002, -0.00015, 0))
  cut_stub_p_ch3 = polyline((0.002011, -0.0001, 0) (0.001989, -0.0001, 0))
  cut_stub_p_ch3.sweep_along_path(cut_stub_p_ch3_path)
  trace_feed_jf_ch3_path = polyline((0.002, -0.000415, 0) (0.002, -0.001465, 0))
  trace_feed_jf_ch3 = polyline((0.002005, -0.000415, 0) (0.001995, -0.000415, 0))
  trace_feed_jf_ch3.sweep_along_path(trace_feed_jf_ch3_path)
  cut_feed_jf_ch3_path = polyline((0.002, -0.000415, 0) (0.002, -0.001465, 0))
  cut_feed_jf_ch3 = polyline((0.002011, -0.000415, 0) (0.001989, -0.000415, 0))
  cut_feed_jf_ch3.sweep_along_path(cut_feed_jf_ch3_path)
  lead_a_cj_ch3_path = polyline((0.002065501, -0.001615, 0) (0.0020555, -0.001615, 0))
  lead_a_cj_ch3 = polyline((0.002065501, -0.00162, 0) (0.002065501, -0.00161, 0))
  lead_a_cj_ch3.sweep_along_path(lead_a_cj_ch3_path)
  lead_a_sub_cj_ch3_path = polyline((0.002065501, -0.001615, 0) (0.0020555, -0.001615, 0))
  lead_a_sub_cj_ch3 = polyline((0.002065501, -0.001626, 0) (0.002065501, -0.001604, 0))
  lead_a_sub_cj_ch3.sweep_along_path(lead_a_sub_cj_ch3_path)
  lead_b_cj_ch3_path = polyline((0.002134499, -0.001615, 0) (0.0021445, -0.001615, 0))
  lead_b_cj_ch3 = polyline((0.002134499, -0.00161, 0) (0.002134499, -0.00162, 0))
  lead_b_cj_ch3.sweep_along_path(lead_b_cj_ch3_path)
  lead_b_sub_cj_ch3_path = polyline((0.002134499, -0.001615, 0) (0.0021445, -0.001615, 0))
  lead_b_sub_cj_ch3 = polyline((0.002134499, -0.001604, 0) (0.002134499, -0.001626, 0))
  lead_b_sub_cj_ch3.sweep_along_path(lead_b_sub_cj_ch3_path)
  trace_stub_f_ch3_path = polyline((0.0020355, -0.001615, 0) (0.0020555, -0.001615, 0))
  trace_stub_f_ch3 = polyline((0.0020355, -0.00161, 0) (0.0020355, -0.00162, 0))
  trace_stub_f_ch3.sweep_along_path(trace_stub_f_ch3_path)
  cut_stub_f_ch3_path = polyline((0.0020355, -0.001615, 0) (0.0020555, -0.001615, 0))
  cut_stub_f_ch3 = polyline((0.0020355, -0.001604, 0) (0.0020355, -0.001626, 0))
  cut_stub_f_ch3.sweep_along_path(cut_stub_f_ch3_path)
  trace_stub_r_ch3_path = polyline((0.0021645, -0.001615, 0) (0.0021445, -0.001615, 0))
  trace_stub_r_ch3 = polyline((0.0021645, -0.00162, 0) (0.0021645, -0.00161, 0))
  trace_stub_r_ch3.sweep_along_path(trace_stub_r_ch3_path)
  cut_stub_r_ch3_path = polyline((0.0021645, -0.001615, 0) (0.0021445, -0.001615, 0))
  cut_stub_r_ch3 = polyline((0.0021645, -0.001626, 0) (0.0021645, -0.001604, 0))
  cut_stub_r_ch3.sweep_along_path(cut_stub_r_ch3_path)
  trace_filt_ch3_path = polyline(z=0, xy: (0.00145, -0.002045) (0.00145, -0.0027647409) (0.0017, -0.0027647409) (0.0017, -0.002045) (0.002, -0.002045) (0.002, -0.001765))
  trace_filt_ch3_path.fillet(Vertices=trace_filt_ch3_path.vertex(2 of 6, 3 of 6, 4 of 6, 5 of 6) Radius=9.9e-05 Setback=0mm)
  trace_filt_ch3 = polyline((0.001455, -0.002045, 0) (0.001445, -0.002045, 0))
  trace_filt_ch3.sweep_along_path(trace_filt_ch3_path)
  cut_filt_ch3_path = polyline(z=0, xy: (0.00145, -0.002045) (0.00145, -0.0027647409) (0.0017, -0.0027647409) (0.0017, -0.002045) (0.002, -0.002045) (0.002, -0.001765))
  cut_filt_ch3_path.fillet(Vertices=cut_filt_ch3_path.vertex(2 of 6, 3 of 6, 4 of 6, 5 of 6) Radius=9.9e-05 Setback=0mm)
  cut_filt_ch3 = polyline((0.001461, -0.002045, 0) (0.001439, -0.002045, 0))
  cut_filt_ch3.sweep_along_path(cut_filt_ch3_path)
  trace_res_a_ch3_path = polyline((0.0022, -0.002915, 0) (0.0022, -0.001765, 0))
  trace_res_a_ch3 = polyline((0.002195, -0.002915, 0) (0.002205, -0.002915, 0))
  trace_res_a_ch3.sweep_along_path(trace_res_a_ch3_path)
  cut_res_a_ch3_path = polyline((0.0022, -0.002915, 0) (0.0022, -0.001765, 0))
  cut_res_a_ch3 = polyline((0.002189, -0.002915, 0) (0.002211, -0.002915, 0))
  cut_res_a_ch3.sweep_along_path(cut_res_a_ch3_path)
  trace_res_ch3_path = polyline(z=0, xy: (0.00295, -0.000855) (0.00295, -0.001736163) (0.0026, -0.001736163) (0.0026, -0.000855) (0.0022, -0.000855) (0.0022, -0.001465))
  trace_res_ch3_path.fillet(Vertices=trace_res_ch3_path.vertex(2 of 6, 3 of 6, 4 of 6, 5 of 6) Radius=9.9e-05 Setback=0mm)
  trace_res_ch3 = polyline((0.002955, -0.000855, 0) (0.002945, -0.000855, 0))
  trace_res_ch3.sweep_along_path(trace_res_ch3_path)
  cut_res_ch3_path = polyline(z=0, xy: (0.00295, -0.000855) (0.00295, -0.001736163) (0.0026, -0.001736163) (0.0026, -0.000855) (0.0022, -0.000855) (0.0022, -0.001465))
  cut_res_ch3_path.fillet(Vertices=cut_res_ch3_path.vertex(2 of 6, 3 of 6, 4 of 6, 5 of 6) Radius=9.9e-05 Setback=0mm)
  cut_res_ch3 = polyline((0.002961, -0.000855, 0) (0.002939, -0.000855, 0))
  cut_res_ch3.sweep_along_path(cut_res_ch3_path)
  lead_a_cp_ch5_path = polyline((0.0033, 0.000362999, 0) (0.0033, 0.000415, 0))
  lead_a_cp_ch5 = polyline((0.003295, 0.000362999, 0) (0.003305, 0.000362999, 0))
  lead_a_cp_ch5.sweep_along_path(lead_a_cp_ch5_path)
  lead_a_sub_cp_ch5_path = polyline((0.0033, 0.000362999, 0) (0.0033, 0.000415, 0))
  lead_a_sub_cp_ch5 = polyline((0.003289, 0.000362999, 0) (0.003311, 0.000362999, 0))
  lead_a_sub_cp_ch5.sweep_along_path(lead_a_sub_cp_ch5_path)
  lead_b_cp_ch5_path = polyline((0.0033, 0.000262001, 0) (0.0033, 0.00015, 0))
  lead_b_cp_ch5 = polyline((0.003305, 0.000262001, 0) (0.003295, 0.000262001, 0))
  lead_b_cp_ch5.sweep_along_path(lead_b_cp_ch5_path)
  lead_b_sub_cp_ch5_path = polyline((0.0033, 0.000262001, 0) (0.0033, 0.00015, 0))
  lead_b_sub_cp_ch5 = polyline((0.003311, 0.000262001, 0) (0.003289, 0.000262001, 0))
  lead_b_sub_cp_ch5.sweep_along_path(lead_b_sub_cp_ch5_path)
  trace_stub_p_ch5_path = polyline((0.0033, 0.0001, 0) (0.0033, 0.00015, 0))
  trace_stub_p_ch5 = polyline((0.003295, 0.0001, 0) (0.003305, 0.0001, 0))
  trace_stub_p_ch5.sweep_along_path(trace_stub_p_ch5_path)
  cut_stub_p_ch5_path = polyline((0.0033, 0.0001, 0) (0.0033, 0.00015, 0))
  cut_stub_p_ch5 = polyline((0.003289, 0.0001, 0) (0.003311, 0.0001, 0))
  cut_stub_p_ch5.sweep_along_path(cut_stub_p_ch5_path)
  trace_feed_jf_ch5_path = polyline((0.0033, 0.000415, 0) (0.0033, 0.001465, 0))
  trace_feed_jf_ch5 = polyline((0.003295, 0.000415, 0) (0.003305, 0.000415, 0))
  trace_feed_jf_ch5.sweep_along_path(trace_feed_jf_ch5_path)
  cut_feed_jf_ch5_path = polyline((0.0033, 0.000415, 0) (0.0033, 0.001465, 0))
  cut_feed_jf_ch5 = polyline((0.003289, 0.000415, 0) (0.003311, 0.000415, 0))
  cut_feed_jf_ch5.sweep_along_path(cut_feed_jf_ch5_path)
  lead_a_cj_ch5_path = polyline((0.003365501, 0.001615, 0) (0.0033555, 0.001615, 0))
  lead_a_cj_ch5 = polyline((0.003365501, 0.00161, 0) (0.003365501, 0.00162, 0))
  lead_a_cj_ch5.sweep_along_path(lead_a_cj_ch5_path)
  lead_a_sub_cj_ch5_path = polyline((0.003365501, 0.001615, 0) (0.0033555, 0.001615, 0))
  lead_a_sub_cj_ch5 = polyline((0.003365501, 0.001604, 0) (0.003365501, 0.001626, 0))
  lead_a_sub_cj_ch5.sweep_along_path(lead_a_sub_cj_ch5_path)
  lead_b_cj_ch5_path = polyline((0.003434499, 0.001615, 0) (0.0034445, 0.001615, 0))
  lead_b_cj_ch5 = polyline((0.003434499, 0.00162, 0) (0.003434499, 0.00161, 0))
  lead_b_cj_ch5.sweep_along_path(lead_b_cj_ch5_path)
  lead_b_sub_cj_ch5_path = polyline((0.003434499, 0.001615, 0) (0.0034445, 0.001615, 0))
  lead_b_sub_cj_ch5 = polyline((0.003434499, 0.001626, 0) (0.003434499, 0.001604, 0))
  lead_b_sub_cj_ch5.sweep_along_path(lead_b_sub_cj_ch5_path)
  trace_stub_f_ch5_path = polyline((0.0033355, 0.001615, 0) (0.0033555, 0.001615, 0))
  trace_stub_f_ch5 = polyline((0.0033355, 0.00162, 0) (0.0033355, 0.00161, 0))
  trace_stub_f_ch5.sweep_along_path(trace_stub_f_ch5_path)
  cut_stub_f_ch5_path = polyline((0.0033355, 0.001615, 0) (0.0033555, 0.001615, 0))
  cut_stub_f_ch5 = polyline((0.0033355, 0.001626, 0) (0.0033355, 0.001604, 0))
  cut_stub_f_ch5.sweep_along_path(cut_stub_f_ch5_path)
  trace_stub_r_ch5_path = polyline((0.0034645, 0.001615, 0) (0.0034445, 0.001615, 0))
  trace_stub_r_ch5 = polyline((0.0034645, 0.00161, 0) (0.0034645, 0.00162, 0))
  trace_stub_r_ch5.sweep_along_path(trace_stub_r_ch5_path)
  cut_stub_r_ch5_path = polyline((0.0034645, 0.001615, 0) (0.0034445, 0.001615, 0))
  cut_stub_r_ch5 = polyline((0.0034645, 0.001604, 0) (0.0034645, 0.001626, 0))
  cut_stub_r_ch5.sweep_along_path(cut_stub_r_ch5_path)
  trace_filt_ch5_path = polyline(z=0, xy: (0.00275, 0.002045) (0.00275, 0.002643463) (0.003, 0.002643463) (0.003, 0.002045) (0.0033, 0.002045) (0.0033, 0.001765))
  trace_filt_ch5_path.fillet(Vertices=trace_filt_ch5_path.vertex(2 of 6, 3 of 6, 4 of 6, 5 of 6) Radius=9.9e-05 Setback=0mm)
  trace_filt_ch5 = polyline((0.002745, 0.002045, 0) (0.002755, 0.002045, 0))
  trace_filt_ch5.sweep_along_path(trace_filt_ch5_path)
  cut_filt_ch5_path = polyline(z=0, xy: (0.00275, 0.002045) (0.00275, 0.002643463) (0.003, 0.002643463) (0.003, 0.002045) (0.0033, 0.002045) (0.0033, 0.001765))
  cut_filt_ch5_path.fillet(Vertices=cut_filt_ch5_path.vertex(2 of 6, 3 of 6, 4 of 6, 5 of 6) Radius=9.9e-05 Setback=0mm)
  cut_filt_ch5 = polyline((0.002739, 0.002045, 0) (0.002761, 0.002045, 0))
  cut_filt_ch5.sweep_along_path(cut_filt_ch5_path)
  trace_res_a_ch5_path = polyline((0.0035, 0.002915, 0) (0.0035, 0.001765, 0))
  trace_res_a_ch5 = polyline((0.003505, 0.002915, 0) (0.003495, 0.002915, 0))
  trace_res_a_ch5.sweep_along_path(trace_res_a_ch5_path)
  cut_res_a_ch5_path = polyline((0.0035, 0.002915, 0) (0.0035, 0.001765, 0))
  cut_res_a_ch5 = polyline((0.003511, 0.002915, 0) (0.003489, 0.002915, 0))
  cut_res_a_ch5.sweep_along_path(cut_res_a_ch5_path)
  trace_res_ch5_path = polyline(z=0, xy: (0.00425, 0.000855) (0.00425, 0.0016110654) (0.0039, 0.0016110654) (0.0039, 0.000855) (0.0035, 0.000855) (0.0035, 0.001465))
  trace_res_ch5_path.fillet(Vertices=trace_res_ch5_path.vertex(2 of 6, 3 of 6, 4 of 6, 5 of 6) Radius=9.9e-05 Setback=0mm)
  trace_res_ch5 = polyline((0.004245, 0.000855, 0) (0.004255, 0.000855, 0))
  trace_res_ch5.sweep_along_path(trace_res_ch5_path)
  cut_res_ch5_path = polyline(z=0, xy: (0.00425, 0.000855) (0.00425, 0.0016110654) (0.0039, 0.0016110654) (0.0039, 0.000855) (0.0035, 0.000855) (0.0035, 0.001465))
  cut_res_ch5_path.fillet(Vertices=cut_res_ch5_path.vertex(2 of 6, 3 of 6, 4 of 6, 5 of 6) Radius=9.9e-05 Setback=0mm)
  cut_res_ch5 = polyline((0.004239, 0.000855, 0) (0.004261, 0.000855, 0))
  cut_res_ch5.sweep_along_path(cut_res_ch5_path)
  trace_feed_in_path = polyline((-0.00447, 0, 0) (-0.0040325, 0, 0))
  trace_feed_in = polyline((-0.00447, 5e-06, 0) (-0.00447, -5e-06, 0))
  trace_feed_in.sweep_along_path(trace_feed_in_path)
  cut_feed_in_path = polyline((-0.00447, 0, 0) (-0.0040325, 0, 0))
  cut_feed_in = polyline((-0.00447, 1.1e-05, 0) (-0.00447, -1.1e-05, 0))
  cut_feed_in.sweep_along_path(cut_feed_in_path)
  trace_fl_0_path = polyline((-0.0037675, 0, 0) (-0.00335, 0, 0))
  trace_fl_0 = polyline((-0.0037675, 5e-06, 0) (-0.0037675, -5e-06, 0))
  trace_fl_0.sweep_along_path(trace_fl_0_path)
  cut_fl_0_path = polyline((-0.0037675, 0, 0) (-0.00335, 0, 0))
  cut_fl_0 = polyline((-0.0037675, 1.1e-05, 0) (-0.0037675, -1.1e-05, 0))
  cut_fl_0.sweep_along_path(cut_fl_0_path)
  trace_fl_1_path = polyline((-0.00305, 0, 0) (-0.00205, 0, 0))
  trace_fl_1 = polyline((-0.00305, 5e-06, 0) (-0.00305, -5e-06, 0))
  trace_fl_1.sweep_along_path(trace_fl_1_path)
  cut_fl_1_path = polyline((-0.00305, 0, 0) (-0.00205, 0, 0))
  cut_fl_1 = polyline((-0.00305, 1.1e-05, 0) (-0.00305, -1.1e-05, 0))
  cut_fl_1.sweep_along_path(cut_fl_1_path)
  trace_fl_2_path = polyline((-0.00175, 0, 0) (-0.00075, 0, 0))
  trace_fl_2 = polyline((-0.00175, 5e-06, 0) (-0.00175, -5e-06, 0))
  trace_fl_2.sweep_along_path(trace_fl_2_path)
  cut_fl_2_path = polyline((-0.00175, 0, 0) (-0.00075, 0, 0))
  cut_fl_2 = polyline((-0.00175, 1.1e-05, 0) (-0.00175, -1.1e-05, 0))
  cut_fl_2.sweep_along_path(cut_fl_2_path)
  trace_fl_3_path = polyline((-0.00045, 0, 0) (0.00055, 0, 0))
  trace_fl_3 = polyline((-0.00045, 5e-06, 0) (-0.00045, -5e-06, 0))
  trace_fl_3.sweep_along_path(trace_fl_3_path)
  cut_fl_3_path = polyline((-0.00045, 0, 0) (0.00055, 0, 0))
  cut_fl_3 = polyline((-0.00045, 1.1e-05, 0) (-0.00045, -1.1e-05, 0))
  cut_fl_3.sweep_along_path(cut_fl_3_path)
  trace_fl_4_path = polyline((0.00085, 0, 0) (0.00185, 0, 0))
  trace_fl_4 = polyline((0.00085, 5e-06, 0) (0.00085, -5e-06, 0))
  trace_fl_4.sweep_along_path(trace_fl_4_path)
  cut_fl_4_path = polyline((0.00085, 0, 0) (0.00185, 0, 0))
  cut_fl_4 = polyline((0.00085, 1.1e-05, 0) (0.00085, -1.1e-05, 0))
  cut_fl_4.sweep_along_path(cut_fl_4_path)
  trace_fl_5_path = polyline((0.00215, 0, 0) (0.00315, 0, 0))
  trace_fl_5 = polyline((0.00215, 5e-06, 0) (0.00215, -5e-06, 0))
  trace_fl_5.sweep_along_path(trace_fl_5_path)
  cut_fl_5_path = polyline((0.00215, 0, 0) (0.00315, 0, 0))
  cut_fl_5 = polyline((0.00215, 1.1e-05, 0) (0.00215, -1.1e-05, 0))
  cut_fl_5.sweep_along_path(cut_fl_5_path)
  trace_fl_6_path = polyline((0.00345, 0, 0) (0.00447, 0, 0))
  trace_fl_6 = polyline((0.00345, 5e-06, 0) (0.00345, -5e-06, 0))
  trace_fl_6.sweep_along_path(trace_fl_6_path)
  cut_fl_6_path = polyline((0.00345, 0, 0) (0.00447, 0, 0))
  cut_fl_6 = polyline((0.00345, 1.1e-05, 0) (0.00345, -1.1e-05, 0))
  cut_fl_6.sweep_along_path(cut_fl_6_path)
  plate_cin = polyline(z=0, xy: (-0.0039125, -7e-05) (-0.0039132841, -6.9961478e-05) (-0.0039140607, -6.9846282e-05) (-0.0039148223, -6.9655523e-05) (-0.0039155615, -6.9391036e-05) (-0.0039162712, -6.905537e-05) (-0.0039169446, -6.8651757e-05) (-0.0039175751, -6.8184084e-05) (-0.0039181569, -6.7656854e-05) (-0.0039186841, -6.7075146e-05) (-0.0039191518, -6.6444562e-05) (-0.0039195554, -6.5771174e-05) (-0.003919891, -6.5061467e-05) (-0.0039201555, -6.4322277e-05) (-0.0039203463, -6.3560723e-05) (-0.0039204615, -6.2784137e-05) (-0.0039205, -6.2e-05) (-0.0039205, 6.2e-05) (-0.0039204615, 6.2784137e-05) (-0.0039203463, 6.3560723e-05) (-0.0039201555, 6.4322277e-05) (-0.003919891, 6.5061467e-05) (-0.0039195554, 6.5771174e-05) (-0.0039191518, 6.6444562e-05) (-0.0039186841, 6.7075146e-05) (-0.0039181569, 6.7656854e-05) (-0.0039175751, 6.8184084e-05) (-0.0039169446, 6.8651757e-05) (-0.0039162712, 6.905537e-05) (-0.0039155615, 6.9391036e-05) (-0.0039148223, 6.9655523e-05) (-0.0039140607, 6.9846282e-05) (-0.0039132841, 6.9961478e-05) (-0.0039125, 7e-05) (-0.0038875, 7e-05) (-0.0038867159, 6.9961478e-05) (-0.0038859393, 6.9846282e-05) (-0.0038851777, 6.9655523e-05) (-0.0038844385, 6.9391036e-05) (-0.0038837288, 6.905537e-05) (-0.0038830554, 6.8651757e-05) (-0.0038824249, 6.8184084e-05) (-0.0038818431, 6.7656854e-05) (-0.0038813159, 6.7075146e-05) (-0.0038808482, 6.6444562e-05) (-0.0038804446, 6.5771174e-05) (-0.003880109, 6.5061467e-05) (-0.0038798445, 6.4322277e-05) (-0.0038796537, 6.3560723e-05) (-0.0038795385, 6.2784137e-05) (-0.0038795, 6.2e-05) (-0.0038795, -6.2e-05) (-0.0038795385, -6.2784137e-05) (-0.0038796537, -6.3560723e-05) (-0.0038798445, -6.4322277e-05) (-0.003880109, -6.5061467e-05) (-0.0038804446, -6.5771174e-05) (-0.0038808482, -6.6444562e-05) (-0.0038813159, -6.7075146e-05) (-0.0038818431, -6.7656854e-05) (-0.0038824249, -6.8184084e-05) (-0.0038830554, -6.8651757e-05) (-0.0038837288, -6.905537e-05) (-0.0038844385, -6.9391036e-05) (-0.0038851777, -6.9655523e-05) (-0.0038859393, -6.9846282e-05) (-0.0038867159, -6.9961478e-05) (-0.0038875, -7e-05) (-0.0039125, -7e-05), closed, covered)
  frame_cin = polyline(z=0, xy: (-0.0039285, -7e-05) (-0.0039284615, -7.0784137e-05) (-0.0039283463, -7.1560723e-05) (-0.0039281555, -7.2322277e-05) (-0.003927891, -7.3061467e-05) (-0.0039275554, -7.3771174e-05) (-0.0039271518, -7.4444562e-05) (-0.0039266841, -7.5075146e-05) (-0.0039261569, -7.5656854e-05) (-0.0039255751, -7.6184084e-05) (-0.0039249446, -7.6651757e-05) (-0.0039242712, -7.705537e-05) (-0.0039235615, -7.7391036e-05) (-0.0039228223, -7.7655523e-05) (-0.0039220607, -7.7846282e-05) (-0.0039212841, -7.7961478e-05) (-0.0039205, -7.8e-05) (-0.0038795, -7.8e-05) (-0.0038787159, -7.7961478e-05) (-0.0038779393, -7.7846282e-05) (-0.0038771777, -7.7655523e-05) (-0.0038764385, -7.7391036e-05) (-0.0038757288, -7.705537e-05) (-0.0038750554, -7.6651757e-05) (-0.0038744249, -7.6184084e-05) (-0.0038738431, -7.5656854e-05) (-0.0038733159, -7.5075146e-05) (-0.0038728482, -7.4444562e-05) (-0.0038724446, -7.3771174e-05) (-0.003872109, -7.3061467e-05) (-0.0038718445, -7.2322277e-05) (-0.0038716537, -7.1560723e-05) (-0.0038715385, -7.0784137e-05) (-0.0038715, -7e-05) (-0.0038715, -1.909818e-05) (-0.0038714952, -1.8901939e-05) (-0.0038714711, -1.8412015e-05) (-0.0038714327, -1.80216e-05) (-0.0038713751, -1.7633541e-05) (-0.0038712986, -1.7248774e-05) (-0.0038712032, -1.6868226e-05) (-0.0038710894, -1.6492814e-05) (-0.0038709572, -1.6123441e-05) (-0.0038708071, -1.5760999e-05) (-0.0038706393, -1.540636e-05) (-0.0038704544, -1.5060378e-05) (-0.0038702527, -1.4723887e-05) (-0.0038700348, -1.4397697e-05) (-0.0038698011, -1.4082595e-05) (-0.0038695522, -1.3779339e-05) (-0.0038692887, -1.348866e-05) (-0.0038690113, -1.3211259e-05) (-0.0038687207, -1.2947803e-05) (-0.0038684174, -1.2698928e-05) (-0.0038681023, -1.2465232e-05) (-0.0038677761, -1.2247279e-05) (-0.0038674396, -1.2045594e-05) (-0.0038670936, -1.1860663e-05) (-0.003866739, -1.1692931e-05) (-0.0038663766, -1.1542802e-05) (-0.0038660072, -1.1410639e-05) (-0.0038656318, -1.1296759e-05) (-0.0038652512, -1.1201436e-05) (-0.0038648665, -1.1124902e-05) (-0.0038644784, -1.1067338e-05) (-0.003864088, -1.1028886e-05) (-0.0038635981, -1.1004817e-05) (-0.0038634018, -1.1e-05) (-0.0038155982, -1.1e-05) (-0.0038154019, -1.1004817e-05) (-0.003814912, -1.1028886e-05) (-0.0038145216, -1.1067338e-05) (-0.0038141335, -1.1124902e-05) (-0.0038137488, -1.1201436e-05) (-0.0038133682, -1.1296759e-05) (-0.0038129928, -1.1410639e-05) (-0.0038126234, -1.1542802e-05) (-0.003812261, -1.1692931e-05) (-0.0038119064, -1.1860663e-05) (-0.0038115604, -1.2045594e-05) (-0.0038112239, -1.2247279e-05) (-0.0038108977, -1.2465232e-05) (-0.0038105826, -1.2698928e-05) (-0.0038102793, -1.2947803e-05) (-0.0038099887, -1.3211259e-05) (-0.0038097113, -1.348866e-05) (-0.0038094478, -1.3779339e-05) (-0.0038091989, -1.4082595e-05) (-0.0038089652, -1.4397697e-05) (-0.0038087473, -1.4723887e-05) (-0.0038085456, -1.5060378e-05) (-0.0038083607, -1.540636e-05) (-0.0038081929, -1.5760999e-05) (-0.0038080428, -1.6123441e-05) (-0.0038079106, -1.6492814e-05) (-0.0038077968, -1.6868226e-05) (-0.0038077014, -1.7248774e-05) (-0.0038076249, -1.7633541e-05) (-0.0038075673, -1.80216e-05) (-0.0038075289, -1.8412015e-05) (-0.0038075048, -1.8901939e-05) (-0.0038075, -1.909818e-05) (-0.0038075, -0.00012690182) (-0.0038075048, -0.00012709806) (-0.0038075289, -0.00012758798) (-0.0038075673, -0.0001279784) (-0.0038076249, -0.00012836646) (-0.0038077014, -0.00012875123) (-0.0038077968, -0.00012913177) (-0.0038079106, -0.00012950719) (-0.0038080428, -0.00012987656) (-0.0038081929, -0.000130239) (-0.0038083607, -0.00013059364) (-0.0038085456, -0.00013093962) (-0.0038087473, -0.00013127611) (-0.0038089652, -0.0001316023) (-0.0038091989, -0.00013191741) (-0.0038094478, -0.00013222066) (-0.0038097113, -0.00013251134) (-0.0038099887, -0.00013278874) (-0.0038102793, -0.0001330522) (-0.0038105826, -0.00013330107) (-0.0038108977, -0.00013353477) (-0.0038112239, -0.00013375272) (-0.0038115604, -0.00013395441) (-0.0038119064, -0.00013413934) (-0.003812261, -0.00013430707) (-0.0038126234, -0.0001344572) (-0.0038129928, -0.00013458936) (-0.0038133682, -0.00013470324) (-0.0038137488, -0.00013479856) (-0.0038141335, -0.0001348751) (-0.0038145216, -0.00013493266) (-0.003814912, -0.00013497111) (-0.0038154019, -0.00013499518) (-0.0038155982, -0.000135) (-0.0039724018, -0.000135) (-0.0039725981, -0.00013499518) (-0.003973088, -0.00013497111) (-0.0039734784, -0.00013493266) (-0.0039738665, -0.0001348751) (-0.0039742512, -0.00013479856) (-0.0039746318, -0.00013470324) (-0.0039750072, -0.00013458936) (-0.0039753766, -0.0001344572) (-0.003975739, -0.00013430707) (-0.0039760936, -0.00013413934) (-0.0039764396, -0.00013395441) (-0.0039767761, -0.00013375272) (-0.0039771023, -0.00013353477) (-0.0039774174, -0.00013330107) (-0.0039777207, -0.0001330522) (-0.0039780113, -0.00013278874) (-0.0039782887, -0.00013251134) (-0.0039785522, -0.00013222066) (-0.0039788011, -0.00013191741) (-0.0039790348, -0.0001316023) (-0.0039792527, -0.00013127611) (-0.0039794544, -0.00013093962) (-0.0039796393, -0.00013059364) (-0.0039798071, -0.000130239) (-0.0039799572, -0.00012987656) (-0.0039800894, -0.00012950719) (-0.0039802032, -0.00012913177) (-0.0039802986, -0.00012875123) (-0.0039803751, -0.00012836646) (-0.0039804327, -0.0001279784) (-0.0039804711, -0.00012758798) (-0.0039804952, -0.00012709806) (-0.0039805, -0.00012690182) (-0.0039805, 0.00012690182) (-0.0039804952, 0.00012709806) (-0.0039804711, 0.00012758798) (-0.0039804327, 0.0001279784) (-0.0039803751, 0.00012836646) (-0.0039802986, 0.00012875123) (-0.0039802032, 0.00012913177) (-0.0039800894, 0.00012950719) (-0.0039799572, 0.00012987656) (-0.0039798071, 0.000130239) (-0.0039796393, 0.00013059364) (-0.0039794544, 0.00013093962) (-0.0039792527, 0.00013127611) (-0.0039790348, 0.0001316023) (-0.0039788011, 0.00013191741) (-0.0039785522, 0.00013222066) (-0.0039782887, 0.00013251134) (-0.0039780113, 0.00013278874) (-0.0039777207, 0.0001330522) (-0.0039774174, 0.00013330107) (-0.0039771023, 0.00013353477) (-0.0039767761, 0.00013375272) (-0.0039764396, 0.00013395441) (-0.0039760936, 0.00013413934) (-0.003975739, 0.00013430707) (-0.0039753766, 0.0001344572) (-0.0039750072, 0.00013458936) (-0.0039746318, 0.00013470324) (-0.0039742512, 0.00013479856) (-0.0039738665, 0.0001348751) (-0.0039734784, 0.00013493266) (-0.003973088, 0.00013497111) (-0.0039725981, 0.00013499518) (-0.0039724018, 0.000135) (-0.0038155982, 0.000135) (-0.0038154019, 0.00013499518) (-0.003814912, 0.00013497111) (-0.0038145216, 0.00013493266) (-0.0038141335, 0.0001348751) (-0.0038137488, 0.00013479856) (-0.0038133682, 0.00013470324) (-0.0038129928, 0.00013458936) (-0.0038126234, 0.0001344572) (-0.003812261, 0.00013430707) (-0.0038119064, 0.00013413934) (-0.0038115604, 0.00013395441) (-0.0038112239, 0.00013375272) (-0.0038108977, 0.00013353477) (-0.0038105826, 0.00013330107) (-0.0038102793, 0.0001330522) (-0.0038099887, 0.00013278874) (-0.0038097113, 0.00013251134) (-0.0038094478, 0.00013222066) (-0.0038091989, 0.00013191741) (-0.0038089652, 0.0001316023) (-0.0038087473, 0.00013127611) (-0.0038085456, 0.00013093962) (-0.0038083607, 0.00013059364) (-0.0038081929, 0.000130239) (-0.0038080428, 0.00012987656) (-0.0038079106, 0.00012950719) (-0.0038077968, 0.00012913177) (-0.0038077014, 0.00012875123) (-0.0038076249, 0.00012836646) (-0.0038075673, 0.0001279784) (-0.0038075289, 0.00012758798) (-0.0038075048, 0.00012709806) (-0.0038075, 0.00012690182) (-0.0038075, 1.909818e-05) (-0.0038075048, 1.8901939e-05) (-0.0038075289, 1.8412015e-05) (-0.0038075673, 1.80216e-05) (-0.0038076249, 1.7633541e-05) (-0.0038077014, 1.7248774e-05) (-0.0038077968, 1.6868226e-05) (-0.0038079106, 1.6492814e-05) (-0.0038080428, 1.6123441e-05) (-0.0038081929, 1.5760999e-05) (-0.0038083607, 1.540636e-05) (-0.0038085456, 1.5060378e-05) (-0.0038087473, 1.4723887e-05) (-0.0038089652, 1.4397697e-05) (-0.0038091989, 1.4082595e-05) (-0.0038094478, 1.3779339e-05) (-0.0038097113, 1.348866e-05) (-0.0038099887, 1.3211259e-05) (-0.0038102793, 1.2947803e-05) (-0.0038105826, 1.2698928e-05) (-0.0038108977, 1.2465232e-05) (-0.0038112239, 1.2247279e-05) (-0.0038115604, 1.2045594e-05) (-0.0038119064, 1.1860663e-05) (-0.003812261, 1.1692931e-05) (-0.0038126234, 1.1542802e-05) (-0.0038129928, 1.1410639e-05) (-0.0038133682, 1.1296759e-05) (-0.0038137488, 1.1201436e-05) (-0.0038141335, 1.1124902e-05) (-0.0038145216, 1.1067338e-05) (-0.003814912, 1.1028886e-05) (-0.0038154019, 1.1004817e-05) (-0.0038155982, 1.1e-05) (-0.0038634018, 1.1e-05) (-0.0038635981, 1.1004817e-05) (-0.003864088, 1.1028886e-05) (-0.0038644784, 1.1067338e-05) (-0.0038648665, 1.1124902e-05) (-0.0038652512, 1.1201436e-05) (-0.0038656318, 1.1296759e-05) (-0.0038660072, 1.1410639e-05) (-0.0038663766, 1.1542802e-05) (-0.003866739, 1.1692931e-05) (-0.0038670936, 1.1860663e-05) (-0.0038674396, 1.2045594e-05) (-0.0038677761, 1.2247279e-05) (-0.0038681023, 1.2465232e-05) (-0.0038684174, 1.2698928e-05) (-0.0038687207, 1.2947803e-05) (-0.0038690113, 1.3211259e-05) (-0.0038692887, 1.348866e-05) (-0.0038695522, 1.3779339e-05) (-0.0038698011, 1.4082595e-05) (-0.0038700348, 1.4397697e-05) (-0.0038702527, 1.4723887e-05) (-0.0038704544, 1.5060378e-05) (-0.0038706393, 1.540636e-05) (-0.0038708071, 1.5760999e-05) (-0.0038709572, 1.6123441e-05) (-0.0038710894, 1.6492814e-05) (-0.0038712032, 1.6868226e-05)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, closed, covered)
  pocket_cin = polyline(z=0, xy: (-0.0039925, -0.000135) (-0.0039925, 0.000135) (-0.0039924422, 0.00013617621) (-0.0039922694, 0.00013734108) (-0.0039919833, 0.00013848342) (-0.0039915866, 0.0001395922) (-0.0039910831, 0.00014065676) (-0.0039904776, 0.00014166684) (-0.0039897761, 0.00014261272) (-0.0039889853, 0.00014348528) (-0.0039881127, 0.00014427613) (-0.0039871668, 0.00014497764) (-0.0039861568, 0.00014558305) (-0.0039850922, 0.00014608655) (-0.0039839834, 0.00014648328) (-0.0039828411, 0.00014676942) (-0.0039816762, 0.00014694222) (-0.0039805, 0.000147) (-0.0038075, 0.000147) (-0.0038063238, 0.00014694222) (-0.0038051589, 0.00014676942) (-0.0038040166, 0.00014648328) (-0.0038029078, 0.00014608655) (-0.0038018432, 0.00014558305) (-0.0038008332, 0.00014497764) (-0.0037998873, 0.00014427613) (-0.0037990147, 0.00014348528) (-0.0037982239, 0.00014261272) (-0.0037975224, 0.00014166684) (-0.0037969169, 0.00014065676) (-0.0037964134, 0.0001395922) (-0.0037960167, 0.00013848342) (-0.0037957306, 0.00013734108) (-0.0037955578, 0.00013617621) (-0.0037955, 0.000135) (-0.0037955, -0.000135) (-0.0037955578, -0.00013617621) (-0.0037957306, -0.00013734108) (-0.0037960167, -0.00013848342) (-0.0037964134, -0.0001395922) (-0.0037969169, -0.00014065676) (-0.0037975224, -0.00014166684) (-0.0037982239, -0.00014261272) (-0.0037990147, -0.00014348528) (-0.0037998873, -0.00014427613) (-0.0038008332, -0.00014497764) (-0.0038018432, -0.00014558305) (-0.0038029078, -0.00014608655) (-0.0038040166, -0.00014648328) (-0.0038051589, -0.00014676942) (-0.0038063238, -0.00014694222) (-0.0038075, -0.000147) (-0.0039805, -0.000147) (-0.0039816762, -0.00014694222) (-0.0039828411, -0.00014676942) (-0.0039839834, -0.00014648328) (-0.0039850922, -0.00014608655) (-0.0039861568, -0.00014558305) (-0.0039871668, -0.00014497764) (-0.0039881127, -0.00014427613) (-0.0039889853, -0.00014348528) (-0.0039897761, -0.00014261272) (-0.0039904776, -0.00014166684) (-0.0039910831, -0.00014065676) (-0.0039915866, -0.0001395922) (-0.0039919833, -0.00013848342) (-0.0039922694, -0.00013734108) (-0.0039924422, -0.00013617621) (-0.0039925, -0.000135), closed, covered)
  tap_trace_n0_ch2 = polyline(z=0, xy: (-0.003205, -0.0001) (-0.003205, -5e-06) (-0.00335, -5e-06) (-0.00335, 5e-06) (-0.00305, 5e-06) (-0.00305, -5e-06) (-0.003195, -5e-06) (-0.003195, -0.0001) (-0.003205, -0.0001), closed, covered)
  tap_cut_n0_ch2 = polyline(z=0, xy: (-0.003211, -0.0001) (-0.003211, -1.1e-05) (-0.00335, -1.1e-05) (-0.00335, 1.1e-05) (-0.00305, 1.1e-05) (-0.00305, -1.1e-05) (-0.003189, -1.1e-05) (-0.003189, -0.0001) (-0.003211, -0.0001), closed, covered)
  plate_cp_ch2 = polyline(z=0, xy: (-0.0031175, -0.000295) (-0.0031175385, -0.00029578414) (-0.0031176537, -0.00029656072) (-0.0031178445, -0.00029732228) (-0.003118109, -0.00029806147) (-0.0031184446, -0.00029877117) (-0.0031188482, -0.00029944456) (-0.0031193159, -0.00030007515) (-0.0031198431, -0.00030065685) (-0.0031204249, -0.00030118408) (-0.0031210554, -0.00030165176) (-0.0031217288, -0.00030205537) (-0.0031224385, -0.00030239104) (-0.0031231777, -0.00030265552) (-0.0031239393, -0.00030284628) (-0.0031247159, -0.00030296148) (-0.0031255, -0.000303) (-0.0032745, -0.000303) (-0.0032752841, -0.00030296148) (-0.0032760607, -0.00030284628) (-0.0032768223, -0.00030265552) (-0.0032775615, -0.00030239104) (-0.0032782712, -0.00030205537) (-0.0032789446, -0.00030165176) (-0.0032795751, -0.00030118408) (-0.0032801569, -0.00030065685) (-0.0032806841, -0.00030007515) (-0.0032811518, -0.00029944456) (-0.0032815554, -0.00029877117) (-0.003281891, -0.00029806147) (-0.0032821555, -0.00029732228) (-0.0032823463, -0.00029656072) (-0.0032824615, -0.00029578414) (-0.0032825, -0.000295) (-0.0032825, -0.00027) (-0.0032824615, -0.00026921586) (-0.0032823463, -0.00026843928) (-0.0032821555, -0.00026767772) (-0.003281891, -0.00026693853) (-0.0032815554, -0.00026622883) (-0.0032811518, -0.00026555544) (-0.0032806841, -0.00026492485) (-0.0032801569, -0.00026434315) (-0.0032795751, -0.00026381592) (-0.0032789446, -0.00026334824) (-0.0032782712, -0.00026294463) (-0.0032775615, -0.00026260896) (-0.0032768223, -0.00026234448) (-0.0032760607, -0.00026215372) (-0.0032752841, -0.00026203852) (-0.0032745, -0.000262) (-0.0031255, -0.000262) (-0.0031247159, -0.00026203852) (-0.0031239393, -0.00026215372) (-0.0031231777, -0.00026234448) (-0.0031224385, -0.00026260896) (-0.0031217288, -0.00026294463) (-0.0031210554, -0.00026334824) (-0.0031204249, -0.00026381592) (-0.0031198431, -0.00026434315) (-0.0031193159, -0.00026492485) (-0.0031188482, -0.00026555544) (-0.0031184446, -0.00026622883) (-0.003118109, -0.00026693853) (-0.0031178445, -0.00026767772) (-0.0031176537, -0.00026843928) (-0.0031175385, -0.00026921586) (-0.0031175, -0.00027) (-0.0031175, -0.000295), closed, covered)
  frame_cp_ch2 = polyline(z=0, xy: (-0.0031175, -0.000311) (-0.0031167159, -0.00031096148) (-0.0031159393, -0.00031084628) (-0.0031151777, -0.00031065552) (-0.0031144385, -0.00031039104) (-0.0031137288, -0.00031005537) (-0.0031130554, -0.00030965176) (-0.0031124249, -0.00030918408) (-0.0031118431, -0.00030865685) (-0.0031113159, -0.00030807515) (-0.0031108482, -0.00030744456) (-0.0031104446, -0.00030677117) (-0.003110109, -0.00030606147) (-0.0031098445, -0.00030532228) (-0.0031096537, -0.00030456072) (-0.0031095385, -0.00030378414) (-0.0031095, -0.000303) (-0.0031095, -0.000262) (-0.0031095385, -0.00026121586) (-0.0031096537, -0.00026043928) (-0.0031098445, -0.00025967772) (-0.003110109, -0.00025893853) (-0.0031104446, -0.00025822883) (-0.0031108482, -0.00025755544) (-0.0031113159, -0.00025692485) (-0.0031118431, -0.00025634315) (-0.0031124249, -0.00025581592) (-0.0031130554, -0.00025534824) (-0.0031137288, -0.00025494463) (-0.0031144385, -0.00025460896) (-0.0031151777, -0.00025434448) (-0.0031159393, -0.00025415372) (-0.0031167159, -0.00025403852) (-0.0031175, -0.000254) (-0.0031809018, -0.000254) (-0.0031810981, -0.00025399518) (-0.003181588, -0.00025397111) (-0.0031819784, -0.00025393266) (-0.0031823665, -0.0002538751) (-0.0031827512, -0.00025379856) (-0.0031831318, -0.00025370324) (-0.0031835072, -0.00025358936) (-0.0031838766, -0.0002534572) (-0.003184239, -0.00025330707) (-0.0031845936, -0.00025313934) (-0.0031849396, -0.00025295441) (-0.0031852761, -0.00025275272) (-0.0031856023, -0.00025253477) (-0.0031859174, -0.00025230107) (-0.0031862207, -0.0002520522) (-0.0031865113, -0.00025178874) (-0.0031867887, -0.00025151134) (-0.0031870522, -0.00025122066) (-0.0031873011, -0.0002509174) (-0.0031875348, -0.0002506023) (-0.0031877527, -0.00025027611) (-0.0031879544, -0.00024993962) (-0.0031881393, -0.00024959364) (-0.0031883071, -0.000249239) (-0.0031884572, -0.00024887656) (-0.0031885894, -0.00024850719) (-0.0031887032, -0.00024813177) (-0.0031887986, -0.00024775123) (-0.0031888751, -0.00024736646) (-0.0031889327, -0.0002469784) (-0.0031889711, -0.00024658799) (-0.0031889952, -0.00024609806) (-0.003189, -0.00024590182) (-0.003189, -0.00019809818) (-0.0031889952, -0.00019790194) (-0.0031889711, -0.00019741201) (-0.0031889327, -0.0001970216) (-0.0031888751, -0.00019663354) (-0.0031887986, -0.00019624877) (-0.0031887032, -0.00019586823) (-0.0031885894, -0.00019549281) (-0.0031884572, -0.00019512344) (-0.0031883071, -0.000194761) (-0.0031881393, -0.00019440636) (-0.0031879544, -0.00019406038) (-0.0031877527, -0.00019372389) (-0.0031875348, -0.0001933977) (-0.0031873011, -0.00019308259) (-0.0031870522, -0.00019277934) (-0.0031867887, -0.00019248866) (-0.0031865113, -0.00019221126) (-0.0031862207, -0.0001919478) (-0.0031859174, -0.00019169893) (-0.0031856023, -0.00019146523) (-0.0031852761, -0.00019124728) (-0.0031849396, -0.00019104559) (-0.0031845936, -0.00019086066) (-0.003184239, -0.00019069293) (-0.0031838766, -0.0001905428) (-0.0031835072, -0.00019041064) (-0.0031831318, -0.00019029676) (-0.0031827512, -0.00019020144) (-0.0031823665, -0.0001901249) (-0.0031819784, -0.00019006734) (-0.003181588, -0.00019002889) (-0.0031810981, -0.00019000482) (-0.0031809018, -0.00019) (-0.0030605982, -0.00019) (-0.0030604019, -0.00019000482) (-0.003059912, -0.00019002889) (-0.0030595216, -0.00019006734) (-0.0030591335, -0.0001901249) (-0.0030587488, -0.00019020144) (-0.0030583682, -0.00019029676) (-0.0030579928, -0.00019041064) (-0.0030576234, -0.0001905428) (-0.003057261, -0.00019069293) (-0.0030569064, -0.00019086066) (-0.0030565604, -0.00019104559) (-0.0030562239, -0.00019124728) (-0.0030558977, -0.00019146523) (-0.0030555826, -0.00019169893) (-0.0030552793, -0.0001919478) (-0.0030549887, -0.00019221126) (-0.0030547113, -0.00019248866) (-0.0030544478, -0.00019277934) (-0.0030541989, -0.00019308259) (-0.0030539652, -0.0001933977) (-0.0030537473, -0.00019372389) (-0.0030535456, -0.00019406038) (-0.0030533607, -0.00019440636) (-0.0030531929, -0.000194761) (-0.0030530428, -0.00019512344) (-0.0030529106, -0.00019549281) (-0.0030527968, -0.00019586823) (-0.0030527014, -0.00019624877) (-0.0030526249, -0.00019663354) (-0.0030525673, -0.0001970216) (-0.0030525289, -0.00019741201) (-0.0030525048, -0.00019790194) (-0.0030525, -0.00019809818) (-0.0030525, -0.00035490182) (-0.0030525048, -0.00035509806) (-0.0030525289, -0.00035558799) (-0.0030525673, -0.0003559784) (-0.0030526249, -0.00035636646) (-0.0030527014, -0.00035675123) (-0.0030527968, -0.00035713177) (-0.0030529106, -0.00035750719) (-0.0030530428, -0.00035787656) (-0.0030531929, -0.000358239) (-0.0030533607, -0.00035859364) (-0.0030535456, -0.00035893962) (-0.0030537473, -0.00035927611) (-0.0030539652, -0.0003596023) (-0.0030541989, -0.00035991741) (-0.0030544478, -0.00036022066) (-0.0030547113, -0.00036051134) (-0.0030549887, -0.00036078874) (-0.0030552793, -0.0003610522) (-0.0030555826, -0.00036130107) (-0.0030558977, -0.00036153477) (-0.0030562239, -0.00036175272) (-0.0030565604, -0.00036195441) (-0.0030569064, -0.00036213934) (-0.003057261, -0.00036230707) (-0.0030576234, -0.0003624572) (-0.0030579928, -0.00036258936) (-0.0030583682, -0.00036270324) (-0.0030587488, -0.00036279856) (-0.0030591335, -0.0003628751) (-0.0030595216, -0.00036293266) (-0.003059912, -0.00036297111) (-0.0030604019, -0.00036299518) (-0.0030605982, -0.000363) (-0.0033394018, -0.000363) (-0.0033395981, -0.00036299518) (-0.003340088, -0.00036297111) (-0.0033404784, -0.00036293266) (-0.0033408665, -0.0003628751) (-0.0033412512, -0.00036279856) (-0.0033416318, -0.00036270324) (-0.0033420072, -0.00036258936) (-0.0033423766, -0.0003624572) (-0.003342739, -0.00036230707) (-0.0033430936, -0.00036213934) (-0.0033434396, -0.00036195441) (-0.0033437761, -0.00036175272) (-0.0033441023, -0.00036153477) (-0.0033444174, -0.00036130107) (-0.0033447207, -0.0003610522) (-0.0033450113, -0.00036078874) (-0.0033452887, -0.00036051134) (-0.0033455522, -0.00036022066) (-0.0033458011, -0.00035991741) (-0.0033460348, -0.0003596023) (-0.0033462527, -0.00035927611) (-0.0033464544, -0.00035893962) (-0.0033466393, -0.00035859364) (-0.0033468071, -0.000358239) (-0.0033469572, -0.00035787656) (-0.0033470894, -0.00035750719) (-0.0033472032, -0.00035713177) (-0.0033472986, -0.00035675123) (-0.0033473751, -0.00035636646) (-0.0033474327, -0.0003559784) (-0.0033474711, -0.00035558799) (-0.0033474952, -0.00035509806) (-0.0033475, -0.00035490182) (-0.0033475, -0.00019809818) (-0.0033474952, -0.00019790194) (-0.0033474711, -0.00019741201) (-0.0033474327, -0.0001970216) (-0.0033473751, -0.00019663354) (-0.0033472986, -0.00019624877) (-0.0033472032, -0.00019586823) (-0.0033470894, -0.00019549281) (-0.0033469572, -0.00019512344) (-0.0033468071, -0.000194761) (-0.0033466393, -0.00019440636) (-0.0033464544, -0.00019406038) (-0.0033462527, -0.00019372389) (-0.0033460348, -0.0001933977) (-0.0033458011, -0.00019308259) (-0.0033455522, -0.00019277934) (-0.0033452887, -0.00019248866) (-0.0033450113, -0.00019221126) (-0.0033447207, -0.0001919478) (-0.0033444174, -0.00019169893) (-0.0033441023, -0.00019146523) (-0.0033437761, -0.00019124728) (-0.0033434396, -0.00019104559) (-0.0033430936, -0.00019086066) (-0.003342739, -0.00019069293) (-0.0033423766, -0.0001905428) (-0.0033420072, -0.00019041064) (-0.0033416318, -0.00019029676) (-0.0033412512, -0.00019020144) (-0.0033408665, -0.0001901249) (-0.0033404784, -0.00019006734) (-0.003340088, -0.00019002889) (-0.0033395981, -0.00019000482) (-0.0033394018, -0.00019) (-0.0032190982, -0.00019) (-0.0032189019, -0.00019000482) (-0.003218412, -0.00019002889) (-0.0032180216, -0.00019006734) (-0.0032176335, -0.0001901249) (-0.0032172488, -0.00019020144) (-0.0032168682, -0.00019029676) (-0.0032164928, -0.00019041064) (-0.0032161234, -0.0001905428) (-0.003215761, -0.00019069293) (-0.0032154064, -0.00019086066) (-0.0032150604, -0.00019104559) (-0.0032147239, -0.00019124728) (-0.0032143977, -0.00019146523) (-0.0032140826, -0.00019169893) (-0.0032137793, -0.0001919478) (-0.0032134887, -0.00019221126) (-0.0032132113, -0.00019248866) (-0.0032129478, -0.00019277934) (-0.0032126989, -0.00019308259) (-0.0032124652, -0.0001933977) (-0.0032122473, -0.00019372389) (-0.0032120456, -0.00019406038) (-0.0032118607, -0.00019440636) (-0.0032116929, -0.000194761) (-0.0032115428, -0.00019512344) (-0.0032114106, -0.00019549281) (-0.0032112968, -0.00019586823) (-0.0032112014, -0.00019624877) (-0.0032111249, -0.00019663354) (-0.0032110673, -0.0001970216) (-0.0032110289, -0.00019741201) (-0.0032110048, -0.00019790194) (-0.003211, -0.00019809818) (-0.003211, -0.00024590182) (-0.0032110048, -0.00024609806) (-0.0032110289, -0.00024658799) (-0.0032110673, -0.0002469784) (-0.0032111249, -0.00024736646) (-0.0032112014, -0.00024775123) (-0.0032112968, -0.00024813177) (-0.0032114106, -0.00024850719) (-0.0032115428, -0.00024887656) (-0.0032116929, -0.000249239) (-0.0032118607, -0.00024959364) (-0.0032120456, -0.00024993962) (-0.0032122473, -0.00025027611) (-0.0032124652, -0.0002506023) (-0.0032126989, -0.0002509174) (-0.0032129478, -0.00025122066) (-0.0032132113, -0.00025151134) (-0.0032134887, -0.00025178874) (-0.0032137793, -0.0002520522) (-0.0032140826, -0.00025230107) (-0.0032143977, -0.00025253477) (-0.0032147239, -0.00025275272) (-0.0032150604, -0.00025295441) (-0.0032154064, -0.00025313934) (-0.003215761, -0.00025330707) (-0.0032161234, -0.0002534572) (-0.0032164928, -0.00025358936) (-0.0032168682, -0.00025370324)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, closed, covered)
  pocket_cp_ch2 = polyline(z=0, xy: (-0.0030525, -0.000375) (-0.0033475, -0.000375) (-0.0033486762, -0.00037494222) (-0.0033498411, -0.00037476942) (-0.0033509834, -0.00037448328) (-0.0033520922, -0.00037408655) (-0.0033531568, -0.00037358305) (-0.0033541668, -0.00037297763) (-0.0033551127, -0.00037227612) (-0.0033559853, -0.00037148528) (-0.0033567761, -0.00037061272) (-0.0033574776, -0.00036966684) (-0.0033580831, -0.00036865676) (-0.0033585866, -0.0003675922) (-0.0033589833, -0.00036648342) (-0.0033592694, -0.00036534108) (-0.0033594422, -0.00036417621) (-0.0033595, -0.000363) (-0.0033595, -0.00019) (-0.0033594422, -0.00018882379) (-0.0033592694, -0.00018765892) (-0.0033589833, -0.00018651658) (-0.0033585866, -0.0001854078) (-0.0033580831, -0.00018434324) (-0.0033574776, -0.00018333316) (-0.0033567761, -0.00018238728) (-0.0033559853, -0.00018151472) (-0.0033551127, -0.00018072388) (-0.0033541668, -0.00018002237) (-0.0033531568, -0.00017941694) (-0.0033520922, -0.00017891345) (-0.0033509834, -0.00017851672) (-0.0033498411, -0.00017823058) (-0.0033486762, -0.00017805778) (-0.0033475, -0.000178) (-0.0030525, -0.000178) (-0.0030513238, -0.00017805778) (-0.0030501589, -0.00017823058) (-0.0030490166, -0.00017851672) (-0.0030479078, -0.00017891345) (-0.0030468432, -0.00017941694) (-0.0030458332, -0.00018002237) (-0.0030448873, -0.00018072388) (-0.0030440147, -0.00018151472) (-0.0030432239, -0.00018238728) (-0.0030425224, -0.00018333316) (-0.0030419169, -0.00018434324) (-0.0030414134, -0.0001854078) (-0.0030410167, -0.00018651658) (-0.0030407306, -0.00018765892) (-0.0030405578, -0.00018882379) (-0.0030405, -0.00019) (-0.0030405, -0.000363) (-0.0030405578, -0.00036417621) (-0.0030407306, -0.00036534108) (-0.0030410167, -0.00036648342) (-0.0030414134, -0.0003675922) (-0.0030419169, -0.00036865676) (-0.0030425224, -0.00036966684) (-0.0030432239, -0.00037061272) (-0.0030440147, -0.00037148528) (-0.0030448873, -0.00037227612) (-0.0030458332, -0.00037297763) (-0.0030468432, -0.00037358305) (-0.0030479078, -0.00037408655) (-0.0030490166, -0.00037448328) (-0.0030501589, -0.00037476942) (-0.0030513238, -0.00037494222) (-0.0030525, -0.000375), closed, covered)
  tap_trace_jf_ch2 = polyline(z=0, xy: (-0.003195, -0.001465) (-0.003195, -0.00161) (-0.0031645, -0.00161) (-0.0031645, -0.00162) (-0.003195, -0.00162) (-0.003195, -0.001765) (-0.003205, -0.001765) (-0.003205, -0.001465) (-0.003195, -0.001465), closed, covered)
  tap_cut_jf_ch2 = polyline(z=0, xy: (-0.003189, -0.001465) (-0.003189, -0.001604) (-0.0031645, -0.001604) (-0.0031645, -0.001626) (-0.003189, -0.001626) (-0.003189, -0.001765) (-0.003211, -0.001765) (-0.003211, -0.001465) (-0.003189, -0.001465), closed, covered)
  tap_trace_jr_ch2 = polyline(z=0, xy: (-0.0030355, -0.00161) (-0.003005, -0.00161) (-0.003005, -0.001465) (-0.002995, -0.001465) (-0.002995, -0.001765) (-0.003005, -0.001765) (-0.003005, -0.00162) (-0.0030355, -0.00162) (-0.0030355, -0.00161), closed, covered)
  tap_cut_jr_ch2 = polyline(z=0, xy: (-0.0030355, -0.001604) (-0.003011, -0.001604) (-0.003011, -0.001465) (-0.002989, -0.001465) (-0.002989, -0.001765) (-0.003011, -0.001765) (-0.003011, -0.001626) (-0.0030355, -0.001626) (-0.0030355, -0.001604), closed, covered)
  head_a_cj_ch2 = polyline(z=0, xy: (-0.0031325, -0.0016475) (-0.003132696, -0.0016474904) (-0.0031328902, -0.0016474616) (-0.0031330806, -0.0016474139) (-0.0031332654, -0.0016473478) (-0.0031334428, -0.0016472638) (-0.0031336111, -0.0016471629) (-0.0031337688, -0.001647046) (-0.0031339142, -0.0016469142) (-0.003134046, -0.0016467688) (-0.0031341629, -0.0016466111) (-0.0031342638, -0.0016464428) (-0.0031343478, -0.0016462654) (-0.0031344139, -0.0016460806) (-0.0031344616, -0.0016458902) (-0.0031344904, -0.001645696) (-0.0031345, -0.0016455) (-0.0031345, -0.0015845) (-0.0031344904, -0.001584304) (-0.0031344616, -0.0015841098) (-0.0031344139, -0.0015839194) (-0.0031343478, -0.0015837346) (-0.0031342638, -0.0015835572) (-0.0031341629, -0.0015833889) (-0.003134046, -0.0015832312) (-0.0031339142, -0.0015830858) (-0.0031337688, -0.001582954) (-0.0031336111, -0.0015828371) (-0.0031334428, -0.0015827362) (-0.0031332654, -0.0015826522) (-0.0031330806, -0.0015825861) (-0.0031328902, -0.0015825384) (-0.003132696, -0.0015825096) (-0.0031325, -0.0015825) (-0.0031115, -0.0015825) (-0.003111304, -0.0015825096) (-0.0031111098, -0.0015825384) (-0.0031109194, -0.0015825861) (-0.0031107346, -0.0015826522) (-0.0031105572, -0.0015827362) (-0.0031103889, -0.0015828371) (-0.0031102312, -0.001582954) (-0.0031100858, -0.0015830858) (-0.003109954, -0.0015832312) (-0.0031098371, -0.0015833889) (-0.0031097362, -0.0015835572) (-0.0031096522, -0.0015837346) (-0.0031095861, -0.0015839194) (-0.0031095384, -0.0015841098) (-0.0031095096, -0.001584304) (-0.0031095, -0.0015845) (-0.0031095, -0.0016455) (-0.0031095096, -0.001645696) (-0.0031095384, -0.0016458902) (-0.0031095861, -0.0016460806) (-0.0031096522, -0.0016462654) (-0.0031097362, -0.0016464428) (-0.0031098371, -0.0016466111) (-0.003109954, -0.0016467688) (-0.0031100858, -0.0016469142) (-0.0031102312, -0.001647046) (-0.0031103889, -0.0016471629) (-0.0031105572, -0.0016472638) (-0.0031107346, -0.0016473478) (-0.0031109194, -0.0016474139) (-0.0031111098, -0.0016474616) (-0.003111304, -0.0016474904) (-0.0031115, -0.0016475) (-0.0031325, -0.0016475), closed, covered)
  head_b_cj_ch2 = polyline(z=0, xy: (-0.0030885, -0.0016475) (-0.003088696, -0.0016474904) (-0.0030888902, -0.0016474616) (-0.0030890806, -0.0016474139) (-0.0030892654, -0.0016473478) (-0.0030894428, -0.0016472638) (-0.0030896111, -0.0016471629) (-0.0030897688, -0.001647046) (-0.0030899142, -0.0016469142) (-0.003090046, -0.0016467688) (-0.0030901629, -0.0016466111) (-0.0030902638, -0.0016464428) (-0.0030903478, -0.0016462654) (-0.0030904139, -0.0016460806) (-0.0030904616, -0.0016458902) (-0.0030904904, -0.001645696) (-0.0030905, -0.0016455) (-0.0030905, -0.0015845) (-0.0030904904, -0.001584304) (-0.0030904616, -0.0015841098) (-0.0030904139, -0.0015839194) (-0.0030903478, -0.0015837346) (-0.0030902638, -0.0015835572) (-0.0030901629, -0.0015833889) (-0.003090046, -0.0015832312) (-0.0030899142, -0.0015830858) (-0.0030897688, -0.001582954) (-0.0030896111, -0.0015828371) (-0.0030894428, -0.0015827362) (-0.0030892654, -0.0015826522) (-0.0030890806, -0.0015825861) (-0.0030888902, -0.0015825384) (-0.003088696, -0.0015825096) (-0.0030885, -0.0015825) (-0.0030675, -0.0015825) (-0.003067304, -0.0015825096) (-0.0030671098, -0.0015825384) (-0.0030669194, -0.0015825861) (-0.0030667346, -0.0015826522) (-0.0030665572, -0.0015827362) (-0.0030663889, -0.0015828371) (-0.0030662312, -0.001582954) (-0.0030660858, -0.0015830858) (-0.003065954, -0.0015832312) (-0.0030658371, -0.0015833889) (-0.0030657362, -0.0015835572) (-0.0030656522, -0.0015837346) (-0.0030655861, -0.0015839194) (-0.0030655384, -0.0015841098) (-0.0030655096, -0.001584304) (-0.0030655, -0.0015845) (-0.0030655, -0.0016455) (-0.0030655096, -0.001645696) (-0.0030655384, -0.0016458902) (-0.0030655861, -0.0016460806) (-0.0030656522, -0.0016462654) (-0.0030657362, -0.0016464428) (-0.0030658371, -0.0016466111) (-0.003065954, -0.0016467688) (-0.0030660858, -0.0016469142) (-0.0030662312, -0.001647046) (-0.0030663889, -0.0016471629) (-0.0030665572, -0.0016472638) (-0.0030667346, -0.0016473478) (-0.0030669194, -0.0016474139) (-0.0030671098, -0.0016474616) (-0.003067304, -0.0016474904) (-0.0030675, -0.0016475) (-0.0030885, -0.0016475), closed, covered)
  pocket_cj_ch2 = polyline(z=0, xy: (-0.0031485, -0.0016635) (-0.003148696, -0.0016634904) (-0.0031488902, -0.0016634616) (-0.0031490806, -0.0016634139) (-0.0031492654, -0.0016633478) (-0.0031494428, -0.0016632638) (-0.0031496111, -0.0016631629) (-0.0031497688, -0.001663046) (-0.0031499142, -0.0016629142) (-0.003150046, -0.0016627688) (-0.0031501629, -0.0016626111) (-0.0031502638, -0.0016624428) (-0.0031503478, -0.0016622654) (-0.0031504139, -0.0016620806) (-0.0031504616, -0.0016618902) (-0.0031504904, -0.001661696) (-0.0031505, -0.0016615) (-0.0031505, -0.0015685) (-0.0031504904, -0.001568304) (-0.0031504616, -0.0015681098) (-0.0031504139, -0.0015679194) (-0.0031503478, -0.0015677346) (-0.0031502638, -0.0015675572) (-0.0031501629, -0.0015673889) (-0.003150046, -0.0015672312) (-0.0031499142, -0.0015670858) (-0.0031497688, -0.001566954) (-0.0031496111, -0.0015668371) (-0.0031494428, -0.0015667362) (-0.0031492654, -0.0015666522) (-0.0031490806, -0.0015665861) (-0.0031488902, -0.0015665384) (-0.003148696, -0.0015665096) (-0.0031485, -0.0015665) (-0.0030515, -0.0015665) (-0.003051304, -0.0015665096) (-0.0030511098, -0.0015665384) (-0.0030509194, -0.0015665861) (-0.0030507346, -0.0015666522) (-0.0030505572, -0.0015667362) (-0.0030503889, -0.0015668371) (-0.0030502312, -0.001566954) (-0.0030500858, -0.0015670858) (-0.003049954, -0.0015672312) (-0.0030498371, -0.0015673889) (-0.0030497362, -0.0015675572) (-0.0030496522, -0.0015677346) (-0.0030495861, -0.0015679194) (-0.0030495384, -0.0015681098) (-0.0030495096, -0.001568304) (-0.0030495, -0.0015685) (-0.0030495, -0.0016615) (-0.0030495096, -0.001661696) (-0.0030495384, -0.0016618902) (-0.0030495861, -0.0016620806) (-0.0030496522, -0.0016622654) (-0.0030497362, -0.0016624428) (-0.0030498371, -0.0016626111) (-0.003049954, -0.0016627688) (-0.0030500858, -0.0016629142) (-0.0030502312, -0.001663046) (-0.0030503889, -0.0016631629) (-0.0030505572, -0.0016632638) (-0.0030507346, -0.0016633478) (-0.0030509194, -0.0016634139) (-0.0030511098, -0.0016634616) (-0.003051304, -0.0016634904) (-0.0030515, -0.0016635) (-0.0031485, -0.0016635), closed, covered)
  tap_trace_n0_ch4 = polyline(z=0, xy: (-0.00175, -5e-06) (-0.00205, -5e-06) (-0.00205, 5e-06) (-0.001905, 5e-06) (-0.001905, 0.0001) (-0.001895, 0.0001) (-0.001895, 5e-06) (-0.00175, 5e-06) (-0.00175, -5e-06), closed, covered)
  tap_cut_n0_ch4 = polyline(z=0, xy: (-0.00175, -1.1e-05) (-0.00205, -1.1e-05) (-0.00205, 1.1e-05) (-0.001911, 1.1e-05) (-0.001911, 0.0001) (-0.001889, 0.0001) (-0.001889, 1.1e-05) (-0.00175, 1.1e-05) (-0.00175, -1.1e-05), closed, covered)
  plate_cp_ch4 = polyline(z=0, xy: (-0.0019825, 0.000295) (-0.0019824615, 0.00029578414) (-0.0019823463, 0.00029656072) (-0.0019821555, 0.00029732228) (-0.001981891, 0.00029806147) (-0.0019815554, 0.00029877117) (-0.0019811518, 0.00029944456) (-0.0019806841, 0.00030007515) (-0.0019801569, 0.00030065685) (-0.0019795751, 0.00030118408) (-0.0019789446, 0.00030165176) (-0.0019782712, 0.00030205537) (-0.0019775615, 0.00030239104) (-0.0019768223, 0.00030265552) (-0.0019760607, 0.00030284628) (-0.0019752841, 0.00030296148) (-0.0019745, 0.000303) (-0.0018255, 0.000303) (-0.0018247159, 0.00030296148) (-0.0018239393, 0.00030284628) (-0.0018231777, 0.00030265552) (-0.0018224385, 0.00030239104) (-0.0018217288, 0.00030205537) (-0.0018210554, 0.00030165176) (-0.0018204249, 0.00030118408) (-0.0018198431, 0.00030065685) (-0.0018193159, 0.00030007515) (-0.0018188482, 0.00029944456) (-0.0018184446, 0.00029877117) (-0.001818109, 0.00029806147) (-0.0018178445, 0.00029732228) (-0.0018176537, 0.00029656072) (-0.0018175385, 0.00029578414) (-0.0018175, 0.000295) (-0.0018175, 0.00027) (-0.0018175385, 0.00026921586) (-0.0018176537, 0.00026843928) (-0.0018178445, 0.00026767772) (-0.001818109, 0.00026693853) (-0.0018184446, 0.00026622883) (-0.0018188482, 0.00026555544) (-0.0018193159, 0.00026492485) (-0.0018198431, 0.00026434315) (-0.0018204249, 0.00026381592) (-0.0018210554, 0.00026334824) (-0.0018217288, 0.00026294463) (-0.0018224385, 0.00026260896) (-0.0018231777, 0.00026234448) (-0.0018239393, 0.00026215372) (-0.0018247159, 0.00026203852) (-0.0018255, 0.000262) (-0.0019745, 0.000262) (-0.0019752841, 0.00026203852) (-0.0019760607, 0.00026215372) (-0.0019768223, 0.00026234448) (-0.0019775615, 0.00026260896) (-0.0019782712, 0.00026294463) (-0.0019789446, 0.00026334824) (-0.0019795751, 0.00026381592) (-0.0019801569, 0.00026434315) (-0.0019806841, 0.00026492485) (-0.0019811518, 0.00026555544) (-0.0019815554, 0.00026622883) (-0.001981891, 0.00026693853) (-0.0019821555, 0.00026767772) (-0.0019823463, 0.00026843928) (-0.0019824615, 0.00026921586) (-0.0019825, 0.00027) (-0.0019825, 0.000295), closed, covered)
  frame_cp_ch4 = polyline(z=0, xy: (-0.0019825, 0.000311) (-0.0019832841, 0.00031096148) (-0.0019840607, 0.00031084628) (-0.0019848223, 0.00031065552) (-0.0019855615, 0.00031039104) (-0.0019862712, 0.00031005537) (-0.0019869446, 0.00030965176) (-0.0019875751, 0.00030918408) (-0.0019881569, 0.00030865685) (-0.0019886841, 0.00030807515) (-0.0019891518, 0.00030744456) (-0.0019895554, 0.00030677117) (-0.001989891, 0.00030606147) (-0.0019901555, 0.00030532228) (-0.0019903463, 0.00030456072) (-0.0019904615, 0.00030378414) (-0.0019905, 0.000303) (-0.0019905, 0.000262) (-0.0019904615, 0.00026121586) (-0.0019903463, 0.00026043928) (-0.0019901555, 0.00025967772) (-0.001989891, 0.00025893853) (-0.0019895554, 0.00025822883) (-0.0019891518, 0.00025755544) (-0.0019886841, 0.00025692485) (-0.0019881569, 0.00025634315) (-0.0019875751, 0.00025581592) (-0.0019869446, 0.00025534824) (-0.0019862712, 0.00025494463) (-0.0019855615, 0.00025460896) (-0.0019848223, 0.00025434448) (-0.0019840607, 0.00025415372) (-0.0019832841, 0.00025403852) (-0.0019825, 0.000254) (-0.0019190982, 0.000254) (-0.0019189019, 0.00025399518) (-0.001918412, 0.00025397111) (-0.0019180216, 0.00025393266) (-0.0019176335, 0.0002538751) (-0.0019172488, 0.00025379856) (-0.0019168682, 0.00025370324) (-0.0019164928, 0.00025358936) (-0.0019161234, 0.0002534572) (-0.001915761, 0.00025330707) (-0.0019154064, 0.00025313934) (-0.0019150604, 0.00025295441) (-0.0019147239, 0.00025275272) (-0.0019143977, 0.00025253477) (-0.0019140826, 0.00025230107) (-0.0019137793, 0.0002520522) (-0.0019134887, 0.00025178874) (-0.0019132113, 0.00025151134) (-0.0019129478, 0.00025122066) (-0.0019126989, 0.0002509174) (-0.0019124652, 0.0002506023) (-0.0019122473, 0.00025027611) (-0.0019120456, 0.00024993962) (-0.0019118607, 0.00024959364) (-0.0019116929, 0.000249239) (-0.0019115428, 0.00024887656) (-0.0019114106, 0.00024850719) (-0.0019112968, 0.00024813177) (-0.0019112014, 0.00024775123) (-0.0019111249, 0.00024736646) (-0.0019110673, 0.0002469784) (-0.0019110289, 0.00024658799) (-0.0019110048, 0.00024609806) (-0.001911, 0.00024590182) (-0.001911, 0.00019809818) (-0.0019110048, 0.00019790194) (-0.0019110289, 0.00019741201) (-0.0019110673, 0.0001970216) (-0.0019111249, 0.00019663354) (-0.0019112014, 0.00019624877) (-0.0019112968, 0.00019586823) (-0.0019114106, 0.00019549281) (-0.0019115428, 0.00019512344) (-0.0019116929, 0.000194761) (-0.0019118607, 0.00019440636) (-0.0019120456, 0.00019406038) (-0.0019122473, 0.00019372389) (-0.0019124652, 0.0001933977) (-0.0019126989, 0.00019308259) (-0.0019129478, 0.00019277934) (-0.0019132113, 0.00019248866) (-0.0019134887, 0.00019221126) (-0.0019137793, 0.0001919478) (-0.0019140826, 0.00019169893) (-0.0019143977, 0.00019146523) (-0.0019147239, 0.00019124728) (-0.0019150604, 0.00019104559) (-0.0019154064, 0.00019086066) (-0.001915761, 0.00019069293) (-0.0019161234, 0.0001905428) (-0.0019164928, 0.00019041064) (-0.0019168682, 0.00019029676) (-0.0019172488, 0.00019020144) (-0.0019176335, 0.0001901249) (-0.0019180216, 0.00019006734) (-0.001918412, 0.00019002889) (-0.0019189019, 0.00019000482) (-0.0019190982, 0.00019) (-0.0020394018, 0.00019) (-0.0020395981, 0.00019000482) (-0.002040088, 0.00019002889) (-0.0020404784, 0.00019006734) (-0.0020408665, 0.0001901249) (-0.0020412512, 0.00019020144) (-0.0020416318, 0.00019029676) (-0.0020420072, 0.00019041064) (-0.0020423766, 0.0001905428) (-0.002042739, 0.00019069293) (-0.0020430936, 0.00019086066) (-0.0020434396, 0.00019104559) (-0.0020437761, 0.00019124728) (-0.0020441023, 0.00019146523) (-0.0020444174, 0.00019169893) (-0.0020447207, 0.0001919478) (-0.0020450113, 0.00019221126) (-0.0020452887, 0.00019248866) (-0.0020455522, 0.00019277934) (-0.0020458011, 0.00019308259) (-0.0020460348, 0.0001933977) (-0.0020462527, 0.00019372389) (-0.0020464544, 0.00019406038) (-0.0020466393, 0.00019440636) (-0.0020468071, 0.000194761) (-0.0020469572, 0.00019512344) (-0.0020470894, 0.00019549281) (-0.0020472032, 0.00019586823) (-0.0020472986, 0.00019624877) (-0.0020473751, 0.00019663354) (-0.0020474327, 0.0001970216) (-0.0020474711, 0.00019741201) (-0.0020474952, 0.00019790194) (-0.0020475, 0.00019809818) (-0.0020475, 0.00035490182) (-0.0020474952, 0.00035509806) (-0.0020474711, 0.00035558799) (-0.0020474327, 0.0003559784) (-0.0020473751, 0.00035636646) (-0.0020472986, 0.00035675123) (-0.0020472032, 0.00035713177) (-0.0020470894, 0.00035750719) (-0.0020469572, 0.00035787656) (-0.0020468071, 0.000358239) (-0.0020466393, 0.00035859364) (-0.0020464544, 0.00035893962) (-0.0020462527, 0.00035927611) (-0.0020460348, 0.0003596023) (-0.0020458011, 0.00035991741) (-0.0020455522, 0.00036022066) (-0.0020452887, 0.00036051134) (-0.0020450113, 0.00036078874) (-0.0020447207, 0.0003610522) (-0.0020444174, 0.00036130107) (-0.0020441023, 0.00036153477) (-0.0020437761, 0.00036175272) (-0.0020434396, 0.00036195441) (-0.0020430936, 0.00036213934) (-0.002042739, 0.00036230707) (-0.0020423766, 0.0003624572) (-0.0020420072, 0.00036258936) (-0.0020416318, 0.00036270324) (-0.0020412512, 0.00036279856) (-0.0020408665, 0.0003628751) (-0.0020404784, 0.00036293266) (-0.002040088, 0.00036297111) (-0.0020395981, 0.00036299518) (-0.0020394018, 0.000363) (-0.0017605982, 0.000363) (-0.0017604019, 0.00036299518) (-0.001759912, 0.00036297111) (-0.0017595216, 0.00036293266) (-0.0017591335, 0.0003628751) (-0.0017587488, 0.00036279856) (-0.0017583682, 0.00036270324) (-0.0017579928, 0.00036258936) (-0.0017576234, 0.0003624572) (-0.001757261, 0.00036230707) (-0.0017569064, 0.00036213934) (-0.0017565604, 0.00036195441) (-0.0017562239, 0.00036175272) (-0.0017558977, 0.00036153477) (-0.0017555826, 0.00036130107) (-0.0017552793, 0.0003610522) (-0.0017549887, 0.00036078874) (-0.0017547113, 0.00036051134) (-0.0017544478, 0.00036022066) (-0.0017541989, 0.00035991741) (-0.0017539652, 0.0003596023) (-0.0017537473, 0.00035927611) (-0.0017535456, 0.00035893962) (-0.0017533607, 0.00035859364) (-0.0017531929, 0.000358239) (-0.0017530428, 0.00035787656) (-0.0017529106, 0.00035750719) (-0.0017527968, 0.00035713177) (-0.0017527014, 0.00035675123) (-0.0017526249, 0.00035636646) (-0.0017525673, 0.0003559784) (-0.0017525289, 0.00035558799) (-0.0017525048, 0.00035509806) (-0.0017525, 0.00035490182) (-0.0017525, 0.00019809818) (-0.0017525048, 0.00019790194) (-0.0017525289, 0.00019741201) (-0.0017525673, 0.0001970216) (-0.0017526249, 0.00019663354) (-0.0017527014, 0.00019624877) (-0.0017527968, 0.00019586823) (-0.0017529106, 0.00019549281) (-0.0017530428, 0.00019512344) (-0.0017531929, 0.000194761) (-0.0017533607, 0.00019440636) (-0.0017535456, 0.00019406038) (-0.0017537473, 0.00019372389) (-0.0017539652, 0.0001933977) (-0.0017541989, 0.00019308259) (-0.0017544478, 0.00019277934) (-0.0017547113, 0.00019248866) (-0.0017549887, 0.00019221126) (-0.0017552793, 0.0001919478) (-0.0017555826, 0.00019169893) (-0.0017558977, 0.00019146523) (-0.0017562239, 0.00019124728) (-0.0017565604, 0.00019104559) (-0.0017569064, 0.00019086066) (-0.001757261, 0.00019069293) (-0.0017576234, 0.0001905428) (-0.0017579928, 0.00019041064) (-0.0017583682, 0.00019029676) (-0.0017587488, 0.00019020144) (-0.0017591335, 0.0001901249) (-0.0017595216, 0.00019006734) (-0.001759912, 0.00019002889) (-0.0017604019, 0.00019000482) (-0.0017605982, 0.00019) (-0.0018809018, 0.00019) (-0.0018810981, 0.00019000482) (-0.001881588, 0.00019002889) (-0.0018819784, 0.00019006734) (-0.0018823665, 0.0001901249) (-0.0018827512, 0.00019020144) (-0.0018831318, 0.00019029676) (-0.0018835072, 0.00019041064) (-0.0018838766, 0.0001905428) (-0.001884239, 0.00019069293) (-0.0018845936, 0.00019086066) (-0.0018849396, 0.00019104559) (-0.0018852761, 0.00019124728) (-0.0018856023, 0.00019146523) (-0.0018859174, 0.00019169893) (-0.0018862207, 0.0001919478) (-0.0018865113, 0.00019221126) (-0.0018867887, 0.00019248866) (-0.0018870522, 0.00019277934) (-0.0018873011, 0.00019308259) (-0.0018875348, 0.0001933977) (-0.0018877527, 0.00019372389) (-0.0018879544, 0.00019406038) (-0.0018881393, 0.00019440636) (-0.0018883071, 0.000194761) (-0.0018884572, 0.00019512344) (-0.0018885894, 0.00019549281) (-0.0018887032, 0.00019586823) (-0.0018887986, 0.00019624877) (-0.0018888751, 0.00019663354) (-0.0018889327, 0.0001970216) (-0.0018889711, 0.00019741201) (-0.0018889952, 0.00019790194) (-0.001889, 0.00019809818) (-0.001889, 0.00024590182) (-0.0018889952, 0.00024609806) (-0.0018889711, 0.00024658799) (-0.0018889327, 0.0002469784) (-0.0018888751, 0.00024736646) (-0.0018887986, 0.00024775123) (-0.0018887032, 0.00024813177) (-0.0018885894, 0.00024850719) (-0.0018884572, 0.00024887656) (-0.0018883071, 0.000249239) (-0.0018881393, 0.00024959364) (-0.0018879544, 0.00024993962) (-0.0018877527, 0.00025027611) (-0.0018875348, 0.0002506023) (-0.0018873011, 0.0002509174) (-0.0018870522, 0.00025122066) (-0.0018867887, 0.00025151134) (-0.0018865113, 0.00025178874) (-0.0018862207, 0.0002520522) (-0.0018859174, 0.00025230107) (-0.0018856023, 0.00025253477) (-0.0018852761, 0.00025275272) (-0.0018849396, 0.00025295441) (-0.0018845936, 0.00025313934) (-0.001884239, 0.00025330707) (-0.0018838766, 0.0002534572) (-0.0018835072, 0.00025358936) (-0.0018831318, 0.00025370324)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, closed, covered)
  pocket_cp_ch4 = polyline(z=0, xy: (-0.0020475, 0.000375) (-0.0017525, 0.000375) (-0.0017513238, 0.00037494222) (-0.0017501589, 0.00037476942) (-0.0017490166, 0.00037448328) (-0.0017479078, 0.00037408655) (-0.0017468432, 0.00037358305) (-0.0017458332, 0.00037297763) (-0.0017448873, 0.00037227612) (-0.0017440147, 0.00037148528) (-0.0017432239, 0.00037061272) (-0.0017425224, 0.00036966684) (-0.0017419169, 0.00036865676) (-0.0017414134, 0.0003675922) (-0.0017410167, 0.00036648342) (-0.0017407306, 0.00036534108) (-0.0017405578, 0.00036417621) (-0.0017405, 0.000363) (-0.0017405, 0.00019) (-0.0017405578, 0.00018882379) (-0.0017407306, 0.00018765892) (-0.0017410167, 0.00018651658) (-0.0017414134, 0.0001854078) (-0.0017419169, 0.00018434324) (-0.0017425224, 0.00018333316) (-0.0017432239, 0.00018238728) (-0.0017440147, 0.00018151472) (-0.0017448873, 0.00018072388) (-0.0017458332, 0.00018002237) (-0.0017468432, 0.00017941694) (-0.0017479078, 0.00017891345) (-0.0017490166, 0.00017851672) (-0.0017501589, 0.00017823058) (-0.0017513238, 0.00017805778) (-0.0017525, 0.000178) (-0.0020475, 0.000178) (-0.0020486762, 0.00017805778) (-0.0020498411, 0.00017823058) (-0.0020509834, 0.00017851672) (-0.0020520922, 0.00017891345) (-0.0020531568, 0.00017941694) (-0.0020541668, 0.00018002237) (-0.0020551127, 0.00018072388) (-0.0020559853, 0.00018151472) (-0.0020567761, 0.00018238728) (-0.0020574776, 0.00018333316) (-0.0020580831, 0.00018434324) (-0.0020585866, 0.0001854078) (-0.0020589833, 0.00018651658) (-0.0020592694, 0.00018765892) (-0.0020594422, 0.00018882379) (-0.0020595, 0.00019) (-0.0020595, 0.000363) (-0.0020594422, 0.00036417621) (-0.0020592694, 0.00036534108) (-0.0020589833, 0.00036648342) (-0.0020585866, 0.0003675922) (-0.0020580831, 0.00036865676) (-0.0020574776, 0.00036966684) (-0.0020567761, 0.00037061272) (-0.0020559853, 0.00037148528) (-0.0020551127, 0.00037227612) (-0.0020541668, 0.00037297763) (-0.0020531568, 0.00037358305) (-0.0020520922, 0.00037408655) (-0.0020509834, 0.00037448328) (-0.0020498411, 0.00037476942) (-0.0020486762, 0.00037494222) (-0.0020475, 0.000375), closed, covered)
  tap_trace_jf_ch4 = polyline(z=0, xy: (-0.001905, 0.001465) (-0.001905, 0.001765) (-0.001895, 0.001765) (-0.001895, 0.00162) (-0.0018645, 0.00162) (-0.0018645, 0.00161) (-0.001895, 0.00161) (-0.001895, 0.001465) (-0.001905, 0.001465), closed, covered)
  tap_cut_jf_ch4 = polyline(z=0, xy: (-0.001911, 0.001465) (-0.001911, 0.001765) (-0.001889, 0.001765) (-0.001889, 0.001626) (-0.0018645, 0.001626) (-0.0018645, 0.001604) (-0.001889, 0.001604) (-0.001889, 0.001465) (-0.001911, 0.001465), closed, covered)
  tap_trace_jr_ch4 = polyline(z=0, xy: (-0.0017355, 0.00162) (-0.001705, 0.00162) (-0.001705, 0.001765) (-0.001695, 0.001765) (-0.001695, 0.001465) (-0.001705, 0.001465) (-0.001705, 0.00161) (-0.0017355, 0.00161) (-0.0017355, 0.00162), closed, covered)
  tap_cut_jr_ch4 = polyline(z=0, xy: (-0.0017355, 0.001626) (-0.001711, 0.001626) (-0.001711, 0.001765) (-0.001689, 0.001765) (-0.001689, 0.001465) (-0.001711, 0.001465) (-0.001711, 0.001604) (-0.0017355, 0.001604) (-0.0017355, 0.001626), closed, covered)
  head_a_cj_ch4 = polyline(z=0, xy: (-0.0018325, 0.0015825) (-0.001832696, 0.0015825096) (-0.0018328902, 0.0015825384) (-0.0018330806, 0.0015825861) (-0.0018332654, 0.0015826522) (-0.0018334428, 0.0015827362) (-0.0018336111, 0.0015828371) (-0.0018337688, 0.001582954) (-0.0018339142, 0.0015830858) (-0.001834046, 0.0015832312) (-0.0018341629, 0.0015833889) (-0.0018342638, 0.0015835572) (-0.0018343478, 0.0015837346) (-0.0018344139, 0.0015839194) (-0.0018344616, 0.0015841098) (-0.0018344904, 0.001584304) (-0.0018345, 0.0015845) (-0.0018345, 0.0016455) (-0.0018344904, 0.001645696) (-0.0018344616, 0.0016458902) (-0.0018344139, 0.0016460806) (-0.0018343478, 0.0016462654) (-0.0018342638, 0.0016464428) (-0.0018341629, 0.0016466111) (-0.001834046, 0.0016467688) (-0.0018339142, 0.0016469142) (-0.0018337688, 0.001647046) (-0.0018336111, 0.0016471629) (-0.0018334428, 0.0016472638) (-0.0018332654, 0.0016473478) (-0.0018330806, 0.0016474139) (-0.0018328902, 0.0016474616) (-0.001832696, 0.0016474904) (-0.0018325, 0.0016475) (-0.0018115, 0.0016475) (-0.001811304, 0.0016474904) (-0.0018111098, 0.0016474616) (-0.0018109194, 0.0016474139) (-0.0018107346, 0.0016473478) (-0.0018105572, 0.0016472638) (-0.0018103889, 0.0016471629) (-0.0018102312, 0.001647046) (-0.0018100858, 0.0016469142) (-0.001809954, 0.0016467688) (-0.0018098371, 0.0016466111) (-0.0018097362, 0.0016464428) (-0.0018096522, 0.0016462654) (-0.0018095861, 0.0016460806) (-0.0018095384, 0.0016458902) (-0.0018095096, 0.001645696) (-0.0018095, 0.0016455) (-0.0018095, 0.0015845) (-0.0018095096, 0.001584304) (-0.0018095384, 0.0015841098) (-0.0018095861, 0.0015839194) (-0.0018096522, 0.0015837346) (-0.0018097362, 0.0015835572) (-0.0018098371, 0.0015833889) (-0.001809954, 0.0015832312) (-0.0018100858, 0.0015830858) (-0.0018102312, 0.001582954) (-0.0018103889, 0.0015828371) (-0.0018105572, 0.0015827362) (-0.0018107346, 0.0015826522) (-0.0018109194, 0.0015825861) (-0.0018111098, 0.0015825384) (-0.001811304, 0.0015825096) (-0.0018115, 0.0015825) (-0.0018325, 0.0015825), closed, covered)
  head_b_cj_ch4 = polyline(z=0, xy: (-0.0017885, 0.0015825) (-0.001788696, 0.0015825096) (-0.0017888902, 0.0015825384) (-0.0017890806, 0.0015825861) (-0.0017892654, 0.0015826522) (-0.0017894428, 0.0015827362) (-0.0017896111, 0.0015828371) (-0.0017897688, 0.001582954) (-0.0017899142, 0.0015830858) (-0.001790046, 0.0015832312) (-0.0017901629, 0.0015833889) (-0.0017902638, 0.0015835572) (-0.0017903478, 0.0015837346) (-0.0017904139, 0.0015839194) (-0.0017904616, 0.0015841098) (-0.0017904904, 0.001584304) (-0.0017905, 0.0015845) (-0.0017905, 0.0016455) (-0.0017904904, 0.001645696) (-0.0017904616, 0.0016458902) (-0.0017904139, 0.0016460806) (-0.0017903478, 0.0016462654) (-0.0017902638, 0.0016464428) (-0.0017901629, 0.0016466111) (-0.001790046, 0.0016467688) (-0.0017899142, 0.0016469142) (-0.0017897688, 0.001647046) (-0.0017896111, 0.0016471629) (-0.0017894428, 0.0016472638) (-0.0017892654, 0.0016473478) (-0.0017890806, 0.0016474139) (-0.0017888902, 0.0016474616) (-0.001788696, 0.0016474904) (-0.0017885, 0.0016475) (-0.0017675, 0.0016475) (-0.001767304, 0.0016474904) (-0.0017671098, 0.0016474616) (-0.0017669194, 0.0016474139) (-0.0017667346, 0.0016473478) (-0.0017665572, 0.0016472638) (-0.0017663889, 0.0016471629) (-0.0017662312, 0.001647046) (-0.0017660858, 0.0016469142) (-0.001765954, 0.0016467688) (-0.0017658371, 0.0016466111) (-0.0017657362, 0.0016464428) (-0.0017656522, 0.0016462654) (-0.0017655861, 0.0016460806) (-0.0017655384, 0.0016458902) (-0.0017655096, 0.001645696) (-0.0017655, 0.0016455) (-0.0017655, 0.0015845) (-0.0017655096, 0.001584304) (-0.0017655384, 0.0015841098) (-0.0017655861, 0.0015839194) (-0.0017656522, 0.0015837346) (-0.0017657362, 0.0015835572) (-0.0017658371, 0.0015833889) (-0.001765954, 0.0015832312) (-0.0017660858, 0.0015830858) (-0.0017662312, 0.001582954) (-0.0017663889, 0.0015828371) (-0.0017665572, 0.0015827362) (-0.0017667346, 0.0015826522) (-0.0017669194, 0.0015825861) (-0.0017671098, 0.0015825384) (-0.001767304, 0.0015825096) (-0.0017675, 0.0015825) (-0.0017885, 0.0015825), closed, covered)
  pocket_cj_ch4 = polyline(z=0, xy: (-0.0018485, 0.0015665) (-0.001848696, 0.0015665096) (-0.0018488902, 0.0015665384) (-0.0018490806, 0.0015665861) (-0.0018492654, 0.0015666522) (-0.0018494428, 0.0015667362) (-0.0018496111, 0.0015668371) (-0.0018497688, 0.001566954) (-0.0018499142, 0.0015670858) (-0.001850046, 0.0015672312) (-0.0018501629, 0.0015673889) (-0.0018502638, 0.0015675572) (-0.0018503478, 0.0015677346) (-0.0018504139, 0.0015679194) (-0.0018504616, 0.0015681098) (-0.0018504904, 0.001568304) (-0.0018505, 0.0015685) (-0.0018505, 0.0016615) (-0.0018504904, 0.001661696) (-0.0018504616, 0.0016618902) (-0.0018504139, 0.0016620806) (-0.0018503478, 0.0016622654) (-0.0018502638, 0.0016624428) (-0.0018501629, 0.0016626111) (-0.001850046, 0.0016627688) (-0.0018499142, 0.0016629142) (-0.0018497688, 0.001663046) (-0.0018496111, 0.0016631629) (-0.0018494428, 0.0016632638) (-0.0018492654, 0.0016633478) (-0.0018490806, 0.0016634139) (-0.0018488902, 0.0016634616) (-0.001848696, 0.0016634904) (-0.0018485, 0.0016635) (-0.0017515, 0.0016635) (-0.001751304, 0.0016634904) (-0.0017511098, 0.0016634616) (-0.0017509194, 0.0016634139) (-0.0017507346, 0.0016633478) (-0.0017505572, 0.0016632638) (-0.0017503889, 0.0016631629) (-0.0017502312, 0.001663046) (-0.0017500858, 0.0016629142) (-0.001749954, 0.0016627688) (-0.0017498371, 0.0016626111) (-0.0017497362, 0.0016624428) (-0.0017496522, 0.0016622654) (-0.0017495861, 0.0016620806) (-0.0017495384, 0.0016618902) (-0.0017495096, 0.001661696) (-0.0017495, 0.0016615) (-0.0017495, 0.0015685) (-0.0017495096, 0.001568304) (-0.0017495384, 0.0015681098) (-0.0017495861, 0.0015679194) (-0.0017496522, 0.0015677346) (-0.0017497362, 0.0015675572) (-0.0017498371, 0.0015673889) (-0.001749954, 0.0015672312) (-0.0017500858, 0.0015670858) (-0.0017502312, 0.001566954) (-0.0017503889, 0.0015668371) (-0.0017505572, 0.0015667362) (-0.0017507346, 0.0015666522) (-0.0017509194, 0.0015665861) (-0.0017511098, 0.0015665384) (-0.001751304, 0.0015665096) (-0.0017515, 0.0015665) (-0.0018485, 0.0015665), closed, covered)
  tap_trace_n0_ch6 = polyline(z=0, xy: (-0.000605, -0.0001) (-0.000605, -5e-06) (-0.00075, -5e-06) (-0.00075, 5e-06) (-0.00045, 5e-06) (-0.00045, -5e-06) (-0.000595, -5e-06) (-0.000595, -0.0001) (-0.000605, -0.0001), closed, covered)
  tap_cut_n0_ch6 = polyline(z=0, xy: (-0.000611, -0.0001) (-0.000611, -1.1e-05) (-0.00075, -1.1e-05) (-0.00075, 1.1e-05) (-0.00045, 1.1e-05) (-0.00045, -1.1e-05) (-0.000589, -1.1e-05) (-0.000589, -0.0001) (-0.000611, -0.0001), closed, covered)
  plate_cp_ch6 = polyline(z=0, xy: (-0.0005175, -0.000295) (-0.00051753852, -0.00029578414) (-0.00051765372, -0.00029656072) (-0.00051784448, -0.00029732228) (-0.00051810896, -0.00029806147) (-0.00051844463, -0.00029877117) (-0.00051884824, -0.00029944456) (-0.00051931592, -0.00030007515) (-0.00051984315, -0.00030065685) (-0.00052042485, -0.00030118408) (-0.00052105544, -0.00030165176) (-0.00052172883, -0.00030205537) (-0.00052243853, -0.00030239104) (-0.00052317772, -0.00030265552) (-0.00052393928, -0.00030284628) (-0.00052471586, -0.00030296148) (-0.0005255, -0.000303) (-0.0006745, -0.000303) (-0.00067528414, -0.00030296148) (-0.00067606072, -0.00030284628) (-0.00067682228, -0.00030265552) (-0.00067756147, -0.00030239104) (-0.00067827117, -0.00030205537) (-0.00067894456, -0.00030165176) (-0.00067957515, -0.00030118408) (-0.00068015685, -0.00030065685) (-0.00068068408, -0.00030007515) (-0.00068115176, -0.00029944456) (-0.00068155537, -0.00029877117) (-0.00068189104, -0.00029806147) (-0.00068215552, -0.00029732228) (-0.00068234628, -0.00029656072) (-0.00068246148, -0.00029578414) (-0.0006825, -0.000295) (-0.0006825, -0.00027) (-0.00068246148, -0.00026921586) (-0.00068234628, -0.00026843928) (-0.00068215552, -0.00026767772) (-0.00068189104, -0.00026693853) (-0.00068155537, -0.00026622883) (-0.00068115176, -0.00026555544) (-0.00068068408, -0.00026492485) (-0.00068015685, -0.00026434315) (-0.00067957515, -0.00026381592) (-0.00067894456, -0.00026334824) (-0.00067827117, -0.00026294463) (-0.00067756147, -0.00026260896) (-0.00067682228, -0.00026234448) (-0.00067606072, -0.00026215372) (-0.00067528414, -0.00026203852) (-0.0006745, -0.000262) (-0.0005255, -0.000262) (-0.00052471586, -0.00026203852) (-0.00052393928, -0.00026215372) (-0.00052317772, -0.00026234448) (-0.00052243853, -0.00026260896) (-0.00052172883, -0.00026294463) (-0.00052105544, -0.00026334824) (-0.00052042485, -0.00026381592) (-0.00051984315, -0.00026434315) (-0.00051931592, -0.00026492485) (-0.00051884824, -0.00026555544) (-0.00051844463, -0.00026622883) (-0.00051810896, -0.00026693853) (-0.00051784448, -0.00026767772) (-0.00051765372, -0.00026843928) (-0.00051753852, -0.00026921586) (-0.0005175, -0.00027) (-0.0005175, -0.000295), closed, covered)
  frame_cp_ch6 = polyline(z=0, xy: (-0.0005175, -0.000311) (-0.00051671586, -0.00031096148) (-0.00051593928, -0.00031084628) (-0.00051517772, -0.00031065552) (-0.00051443853, -0.00031039104) (-0.00051372883, -0.00031005537) (-0.00051305544, -0.00030965176) (-0.00051242485, -0.00030918408) (-0.00051184315, -0.00030865685) (-0.00051131592, -0.00030807515) (-0.00051084824, -0.00030744456) (-0.00051044463, -0.00030677117) (-0.00051010896, -0.00030606147) (-0.00050984448, -0.00030532228) (-0.00050965372, -0.00030456072) (-0.00050953852, -0.00030378414) (-0.0005095, -0.000303) (-0.0005095, -0.000262) (-0.00050953852, -0.00026121586) (-0.00050965372, -0.00026043928) (-0.00050984448, -0.00025967772) (-0.00051010896, -0.00025893853) (-0.00051044463, -0.00025822883) (-0.00051084824, -0.00025755544) (-0.00051131592, -0.00025692485) (-0.00051184315, -0.00025634315) (-0.00051242485, -0.00025581592) (-0.00051305544, -0.00025534824) (-0.00051372883, -0.00025494463) (-0.00051443853, -0.00025460896) (-0.00051517772, -0.00025434448) (-0.00051593928, -0.00025415372) (-0.00051671586, -0.00025403852) (-0.0005175, -0.000254) (-0.00058090182, -0.000254) (-0.00058109806, -0.00025399518) (-0.00058158799, -0.00025397111) (-0.0005819784, -0.00025393266) (-0.00058236646, -0.0002538751) (-0.00058275123, -0.00025379856) (-0.00058313177, -0.00025370324) (-0.00058350719, -0.00025358936) (-0.00058387656, -0.0002534572) (-0.000584239, -0.00025330707) (-0.00058459364, -0.00025313934) (-0.00058493962, -0.00025295441) (-0.00058527611, -0.00025275272) (-0.0005856023, -0.00025253477) (-0.00058591741, -0.00025230107) (-0.00058622066, -0.0002520522) (-0.00058651134, -0.00025178874) (-0.00058678874, -0.00025151134) (-0.0005870522, -0.00025122066) (-0.00058730107, -0.0002509174) (-0.00058753477, -0.0002506023) (-0.00058775272, -0.00025027611) (-0.00058795441, -0.00024993962) (-0.00058813934, -0.00024959364) (-0.00058830707, -0.000249239) (-0.0005884572, -0.00024887656) (-0.00058858936, -0.00024850719) (-0.00058870324, -0.00024813177) (-0.00058879856, -0.00024775123) (-0.0005888751, -0.00024736646) (-0.00058893266, -0.0002469784) (-0.00058897111, -0.00024658799) (-0.00058899518, -0.00024609806) (-0.000589, -0.00024590182) (-0.000589, -0.00019809818) (-0.00058899518, -0.00019790194) (-0.00058897111, -0.00019741201) (-0.00058893266, -0.0001970216) (-0.0005888751, -0.00019663354) (-0.00058879856, -0.00019624877) (-0.00058870324, -0.00019586823) (-0.00058858936, -0.00019549281) (-0.0005884572, -0.00019512344) (-0.00058830707, -0.000194761) (-0.00058813934, -0.00019440636) (-0.00058795441, -0.00019406038) (-0.00058775272, -0.00019372389) (-0.00058753477, -0.0001933977) (-0.00058730107, -0.00019308259) (-0.0005870522, -0.00019277934) (-0.00058678874, -0.00019248866) (-0.00058651134, -0.00019221126) (-0.00058622066, -0.0001919478) (-0.00058591741, -0.00019169893) (-0.0005856023, -0.00019146523) (-0.00058527611, -0.00019124728) (-0.00058493962, -0.00019104559) (-0.00058459364, -0.00019086066) (-0.000584239, -0.00019069293) (-0.00058387656, -0.0001905428) (-0.00058350719, -0.00019041064) (-0.00058313177, -0.00019029676) (-0.00058275123, -0.00019020144) (-0.00058236646, -0.0001901249) (-0.0005819784, -0.00019006734) (-0.00058158799, -0.00019002889) (-0.00058109806, -0.00019000482) (-0.00058090182, -0.00019) (-0.00046059818, -0.00019) (-0.00046040194, -0.00019000482) (-0.00045991201, -0.00019002889) (-0.0004595216, -0.00019006734) (-0.00045913354, -0.0001901249) (-0.00045874877, -0.00019020144) (-0.00045836823, -0.00019029676) (-0.00045799281, -0.00019041064) (-0.00045762344, -0.0001905428) (-0.000457261, -0.00019069293) (-0.00045690636, -0.00019086066) (-0.00045656038, -0.00019104559) (-0.00045622389, -0.00019124728) (-0.0004558977, -0.00019146523) (-0.0004555826, -0.00019169893) (-0.00045527934, -0.0001919478) (-0.00045498866, -0.00019221126) (-0.00045471126, -0.00019248866) (-0.0004544478, -0.00019277934) (-0.00045419893, -0.00019308259) (-0.00045396523, -0.0001933977) (-0.00045374728, -0.00019372389) (-0.00045354559, -0.00019406038) (-0.00045336066, -0.00019440636) (-0.00045319293, -0.000194761) (-0.0004530428, -0.00019512344) (-0.00045291064, -0.00019549281) (-0.00045279676, -0.00019586823) (-0.00045270144, -0.00019624877) (-0.0004526249, -0.00019663354) (-0.00045256734, -0.0001970216) (-0.00045252889, -0.00019741201) (-0.00045250482, -0.00019790194) (-0.0004525, -0.00019809818) (-0.0004525, -0.00035490182) (-0.00045250482, -0.00035509806) (-0.00045252889, -0.00035558799) (-0.00045256734, -0.0003559784) (-0.0004526249, -0.00035636646) (-0.00045270144, -0.00035675123) (-0.00045279676, -0.00035713177) (-0.00045291064, -0.00035750719) (-0.0004530428, -0.00035787656) (-0.00045319293, -0.000358239) (-0.00045336066, -0.00035859364) (-0.00045354559, -0.00035893962) (-0.00045374728, -0.00035927611) (-0.00045396523, -0.0003596023) (-0.00045419893, -0.00035991741) (-0.0004544478, -0.00036022066) (-0.00045471126, -0.00036051134) (-0.00045498866, -0.00036078874) (-0.00045527934, -0.0003610522) (-0.0004555826, -0.00036130107) (-0.0004558977, -0.00036153477) (-0.00045622389, -0.00036175272) (-0.00045656038, -0.00036195441) (-0.00045690636, -0.00036213934) (-0.000457261, -0.00036230707) (-0.00045762344, -0.0003624572) (-0.00045799281, -0.00036258936) (-0.00045836823, -0.00036270324) (-0.00045874877, -0.00036279856) (-0.00045913354, -0.0003628751) (-0.0004595216, -0.00036293266) (-0.00045991201, -0.00036297111) (-0.00046040194, -0.00036299518) (-0.00046059818, -0.000363) (-0.00073940182, -0.000363) (-0.00073959806, -0.00036299518) (-0.00074008799, -0.00036297111) (-0.0007404784, -0.00036293266) (-0.00074086646, -0.0003628751) (-0.00074125123, -0.00036279856) (-0.00074163177, -0.00036270324) (-0.00074200719, -0.00036258936) (-0.00074237656, -0.0003624572) (-0.000742739, -0.00036230707) (-0.00074309364, -0.00036213934) (-0.00074343962, -0.00036195441) (-0.00074377611, -0.00036175272) (-0.0007441023, -0.00036153477) (-0.00074441741, -0.00036130107) (-0.00074472066, -0.0003610522) (-0.00074501134, -0.00036078874) (-0.00074528874, -0.00036051134) (-0.0007455522, -0.00036022066) (-0.00074580107, -0.00035991741) (-0.00074603477, -0.0003596023) (-0.00074625272, -0.00035927611) (-0.00074645441, -0.00035893962) (-0.00074663934, -0.00035859364) (-0.00074680707, -0.000358239) (-0.0007469572, -0.00035787656) (-0.00074708936, -0.00035750719) (-0.00074720324, -0.00035713177) (-0.00074729856, -0.00035675123) (-0.0007473751, -0.00035636646) (-0.00074743266, -0.0003559784) (-0.00074747111, -0.00035558799) (-0.00074749518, -0.00035509806) (-0.0007475, -0.00035490182) (-0.0007475, -0.00019809818) (-0.00074749518, -0.00019790194) (-0.00074747111, -0.00019741201) (-0.00074743266, -0.0001970216) (-0.0007473751, -0.00019663354) (-0.00074729856, -0.00019624877) (-0.00074720324, -0.00019586823) (-0.00074708936, -0.00019549281) (-0.0007469572, -0.00019512344) (-0.00074680707, -0.000194761) (-0.00074663934, -0.00019440636) (-0.00074645441, -0.00019406038) (-0.00074625272, -0.00019372389) (-0.00074603477, -0.0001933977) (-0.00074580107, -0.00019308259) (-0.0007455522, -0.00019277934) (-0.00074528874, -0.00019248866) (-0.00074501134, -0.00019221126) (-0.00074472066, -0.0001919478) (-0.00074441741, -0.00019169893) (-0.0007441023, -0.00019146523) (-0.00074377611, -0.00019124728) (-0.00074343962, -0.00019104559) (-0.00074309364, -0.00019086066) (-0.000742739, -0.00019069293) (-0.00074237656, -0.0001905428) (-0.00074200719, -0.00019041064) (-0.00074163177, -0.00019029676) (-0.00074125123, -0.00019020144) (-0.00074086646, -0.0001901249) (-0.0007404784, -0.00019006734) (-0.00074008799, -0.00019002889) (-0.00073959806, -0.00019000482) (-0.00073940182, -0.00019) (-0.00061909818, -0.00019) (-0.00061890194, -0.00019000482) (-0.00061841201, -0.00019002889) (-0.0006180216, -0.00019006734) (-0.00061763354, -0.0001901249) (-0.00061724877, -0.00019020144) (-0.00061686823, -0.00019029676) (-0.00061649281, -0.00019041064) (-0.00061612344, -0.0001905428) (-0.000615761, -0.00019069293) (-0.00061540636, -0.00019086066) (-0.00061506038, -0.00019104559) (-0.00061472389, -0.00019124728) (-0.0006143977, -0.00019146523) (-0.00061408259, -0.00019169893) (-0.00061377934, -0.0001919478) (-0.00061348866, -0.00019221126) (-0.00061321126, -0.00019248866) (-0.0006129478, -0.00019277934) (-0.00061269893, -0.00019308259) (-0.00061246523, -0.0001933977) (-0.00061224728, -0.00019372389) (-0.00061204559, -0.00019406038) (-0.00061186066, -0.00019440636) (-0.00061169293, -0.000194761) (-0.0006115428, -0.00019512344) (-0.00061141064, -0.00019549281) (-0.00061129676, -0.00019586823) (-0.00061120144, -0.00019624877) (-0.0006111249, -0.00019663354) (-0.00061106734, -0.0001970216) (-0.00061102889, -0.00019741201) (-0.00061100482, -0.00019790194) (-0.000611, -0.00019809818) (-0.000611, -0.00024590182) (-0.00061100482, -0.00024609806) (-0.00061102889, -0.00024658799) (-0.00061106734, -0.0002469784) (-0.0006111249, -0.00024736646) (-0.00061120144, -0.00024775123) (-0.00061129676, -0.00024813177) (-0.00061141064, -0.00024850719) (-0.0006115428, -0.00024887656) (-0.00061169293, -0.000249239) (-0.00061186066, -0.00024959364) (-0.00061204559, -0.00024993962) (-0.00061224728, -0.00025027611) (-0.00061246523, -0.0002506023) (-0.00061269893, -0.0002509174) (-0.0006129478, -0.00025122066) (-0.00061321126, -0.00025151134) (-0.00061348866, -0.00025178874) (-0.00061377934, -0.0002520522) (-0.00061408259, -0.00025230107) (-0.0006143977, -0.00025253477) (-0.00061472389, -0.00025275272) (-0.00061506038, -0.00025295441) (-0.00061540636, -0.00025313934) (-0.000615761, -0.00025330707) (-0.00061612344, -0.0002534572) (-0.00061649281, -0.00025358936) (-0.00061686823, -0.00025370324)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, closed, covered)
  pocket_cp_ch6 = polyline(z=0, xy: (-0.0004525, -0.000375) (-0.0007475, -0.000375) (-0.00074867621, -0.00037494222) (-0.00074984108, -0.00037476942) (-0.00075098342, -0.00037448328) (-0.0007520922, -0.00037408655) (-0.00075315676, -0.00037358305) (-0.00075416684, -0.00037297763) (-0.00075511272, -0.00037227612) (-0.00075598528, -0.00037148528) (-0.00075677612, -0.00037061272) (-0.00075747763, -0.00036966684) (-0.00075808305, -0.00036865676) (-0.00075858655, -0.0003675922) (-0.00075898328, -0.00036648342) (-0.00075926942, -0.00036534108) (-0.00075944222, -0.00036417621) (-0.0007595, -0.000363) (-0.0007595, -0.00019) (-0.00075944222, -0.00018882379) (-0.00075926942, -0.00018765892) (-0.00075898328, -0.00018651658) (-0.00075858655, -0.0001854078) (-0.00075808305, -0.00018434324) (-0.00075747763, -0.00018333316) (-0.00075677612, -0.00018238728) (-0.00075598528, -0.00018151472) (-0.00075511272, -0.00018072388) (-0.00075416684, -0.00018002237) (-0.00075315676, -0.00017941694) (-0.0007520922, -0.00017891345) (-0.00075098342, -0.00017851672) (-0.00074984108, -0.00017823058) (-0.00074867621, -0.00017805778) (-0.0007475, -0.000178) (-0.0004525, -0.000178) (-0.00045132379, -0.00017805778) (-0.00045015892, -0.00017823058) (-0.00044901658, -0.00017851672) (-0.0004479078, -0.00017891345) (-0.00044684324, -0.00017941694) (-0.00044583316, -0.00018002237) (-0.00044488728, -0.00018072388) (-0.00044401472, -0.00018151472) (-0.00044322387, -0.00018238728) (-0.00044252236, -0.00018333316) (-0.00044191695, -0.00018434324) (-0.00044141345, -0.0001854078) (-0.00044101672, -0.00018651658) (-0.00044073058, -0.00018765892) (-0.00044055778, -0.00018882379) (-0.0004405, -0.00019) (-0.0004405, -0.000363) (-0.00044055778, -0.00036417621) (-0.00044073058, -0.00036534108) (-0.00044101672, -0.00036648342) (-0.00044141345, -0.0003675922) (-0.00044191695, -0.00036865676) (-0.00044252236, -0.00036966684) (-0.00044322387, -0.00037061272) (-0.00044401472, -0.00037148528) (-0.00044488728, -0.00037227612) (-0.00044583316, -0.00037297763) (-0.00044684324, -0.00037358305) (-0.0004479078, -0.00037408655) (-0.00044901658, -0.00037448328) (-0.00045015892, -0.00037476942) (-0.00045132379, -0.00037494222) (-0.0004525, -0.000375), closed, covered)
  tap_trace_jf_ch6 = polyline(z=0, xy: (-0.000595, -0.001465) (-0.000595, -0.00161) (-0.0005645, -0.00161) (-0.0005645, -0.00162) (-0.000595, -0.00162) (-0.000595, -0.001765) (-0.000605, -0.001765) (-0.000605, -0.001465) (-0.000595, -0.001465), closed, covered)
  tap_cut_jf_ch6 = polyline(z=0, xy: (-0.000589, -0.001465) (-0.000589, -0.001604) (-0.0005645, -0.001604) (-0.0005645, -0.001626) (-0.000589, -0.001626) (-0.000589, -0.001765) (-0.000611, -0.001765) (-0.000611, -0.001465) (-0.000589, -0.001465), closed, covered)
  tap_trace_jr_ch6 = polyline(z=0, xy: (-0.0004355, -0.00161) (-0.000405, -0.00161) (-0.000405, -0.001465) (-0.000395, -0.001465) (-0.000395, -0.001765) (-0.000405, -0.001765) (-0.000405, -0.00162) (-0.0004355, -0.00162) (-0.0004355, -0.00161), closed, covered)
  tap_cut_jr_ch6 = polyline(z=0, xy: (-0.0004355, -0.001604) (-0.000411, -0.001604) (-0.000411, -0.001465) (-0.000389, -0.001465) (-0.000389, -0.001765) (-0.000411, -0.001765) (-0.000411, -0.001626) (-0.0004355, -0.001626) (-0.0004355, -0.001604), closed, covered)
  head_a_cj_ch6 = polyline(z=0, xy: (-0.0005325, -0.0016475) (-0.00053269603, -0.0016474904) (-0.00053289018, -0.0016474616) (-0.00053308057, -0.0016474139) (-0.00053326537, -0.0016473478) (-0.00053344279, -0.0016472638) (-0.00053361114, -0.0016471629) (-0.00053376879, -0.001647046) (-0.00053391421, -0.0016469142) (-0.00053404602, -0.0016467688) (-0.00053416294, -0.0016466111) (-0.00053426384, -0.0016464428) (-0.00053434776, -0.0016462654) (-0.00053441388, -0.0016460806) (-0.00053446157, -0.0016458902) (-0.00053449037, -0.001645696) (-0.0005345, -0.0016455) (-0.0005345, -0.0015845) (-0.00053449037, -0.001584304) (-0.00053446157, -0.0015841098) (-0.00053441388, -0.0015839194) (-0.00053434776, -0.0015837346) (-0.00053426384, -0.0015835572) (-0.00053416294, -0.0015833889) (-0.00053404602, -0.0015832312) (-0.00053391421, -0.0015830858) (-0.00053376879, -0.001582954) (-0.00053361114, -0.0015828371) (-0.00053344279, -0.0015827362) (-0.00053326537, -0.0015826522) (-0.00053308057, -0.0015825861) (-0.00053289018, -0.0015825384) (-0.00053269603, -0.0015825096) (-0.0005325, -0.0015825) (-0.0005115, -0.0015825) (-0.00051130397, -0.0015825096) (-0.00051110982, -0.0015825384) (-0.00051091943, -0.0015825861) (-0.00051073463, -0.0015826522) (-0.00051055721, -0.0015827362) (-0.00051038886, -0.0015828371) (-0.00051023121, -0.001582954) (-0.00051008579, -0.0015830858) (-0.00050995398, -0.0015832312) (-0.00050983706, -0.0015833889) (-0.00050973616, -0.0015835572) (-0.00050965224, -0.0015837346) (-0.00050958612, -0.0015839194) (-0.00050953843, -0.0015841098) (-0.00050950963, -0.001584304) (-0.0005095, -0.0015845) (-0.0005095, -0.0016455) (-0.00050950963, -0.001645696) (-0.00050953843, -0.0016458902) (-0.00050958612, -0.0016460806) (-0.00050965224, -0.0016462654) (-0.00050973616, -0.0016464428) (-0.00050983706, -0.0016466111) (-0.00050995398, -0.0016467688) (-0.00051008579, -0.0016469142) (-0.00051023121, -0.001647046) (-0.00051038886, -0.0016471629) (-0.00051055721, -0.0016472638) (-0.00051073463, -0.0016473478) (-0.00051091943, -0.0016474139) (-0.00051110982, -0.0016474616) (-0.00051130397, -0.0016474904) (-0.0005115, -0.0016475) (-0.0005325, -0.0016475), closed, covered)
  head_b_cj_ch6 = polyline(z=0, xy: (-0.0004885, -0.0016475) (-0.00048869603, -0.0016474904) (-0.00048889018, -0.0016474616) (-0.00048908057, -0.0016474139) (-0.00048926537, -0.0016473478) (-0.00048944279, -0.0016472638) (-0.00048961114, -0.0016471629) (-0.00048976879, -0.001647046) (-0.00048991421, -0.0016469142) (-0.00049004602, -0.0016467688) (-0.00049016294, -0.0016466111) (-0.00049026384, -0.0016464428) (-0.00049034776, -0.0016462654) (-0.00049041388, -0.0016460806) (-0.00049046157, -0.0016458902) (-0.00049049037, -0.001645696) (-0.0004905, -0.0016455) (-0.0004905, -0.0015845) (-0.00049049037, -0.001584304) (-0.00049046157, -0.0015841098) (-0.00049041388, -0.0015839194) (-0.00049034776, -0.0015837346) (-0.00049026384, -0.0015835572) (-0.00049016294, -0.0015833889) (-0.00049004602, -0.0015832312) (-0.00048991421, -0.0015830858) (-0.00048976879, -0.001582954) (-0.00048961114, -0.0015828371) (-0.00048944279, -0.0015827362) (-0.00048926537, -0.0015826522) (-0.00048908057, -0.0015825861) (-0.00048889018, -0.0015825384) (-0.00048869603, -0.0015825096) (-0.0004885, -0.0015825) (-0.0004675, -0.0015825) (-0.00046730397, -0.0015825096) (-0.00046710982, -0.0015825384) (-0.00046691943, -0.0015825861) (-0.00046673463, -0.0015826522) (-0.00046655721, -0.0015827362) (-0.00046638886, -0.0015828371) (-0.00046623121, -0.001582954) (-0.00046608579, -0.0015830858) (-0.00046595398, -0.0015832312) (-0.00046583706, -0.0015833889) (-0.00046573616, -0.0015835572) (-0.00046565224, -0.0015837346) (-0.00046558612, -0.0015839194) (-0.00046553843, -0.0015841098) (-0.00046550963, -0.001584304) (-0.0004655, -0.0015845) (-0.0004655, -0.0016455) (-0.00046550963, -0.001645696) (-0.00046553843, -0.0016458902) (-0.00046558612, -0.0016460806) (-0.00046565224, -0.0016462654) (-0.00046573616, -0.0016464428) (-0.00046583706, -0.0016466111) (-0.00046595398, -0.0016467688) (-0.00046608579, -0.0016469142) (-0.00046623121, -0.001647046) (-0.00046638886, -0.0016471629) (-0.00046655721, -0.0016472638) (-0.00046673463, -0.0016473478) (-0.00046691943, -0.0016474139) (-0.00046710982, -0.0016474616) (-0.00046730397, -0.0016474904) (-0.0004675, -0.0016475) (-0.0004885, -0.0016475), closed, covered)
  pocket_cj_ch6 = polyline(z=0, xy: (-0.0005485, -0.0016635) (-0.00054869603, -0.0016634904) (-0.00054889018, -0.0016634616) (-0.00054908057, -0.0016634139) (-0.00054926537, -0.0016633478) (-0.00054944279, -0.0016632638) (-0.00054961114, -0.0016631629) (-0.00054976879, -0.001663046) (-0.00054991421, -0.0016629142) (-0.00055004602, -0.0016627688) (-0.00055016294, -0.0016626111) (-0.00055026384, -0.0016624428) (-0.00055034776, -0.0016622654) (-0.00055041388, -0.0016620806) (-0.00055046157, -0.0016618902) (-0.00055049037, -0.001661696) (-0.0005505, -0.0016615) (-0.0005505, -0.0015685) (-0.00055049037, -0.001568304) (-0.00055046157, -0.0015681098) (-0.00055041388, -0.0015679194) (-0.00055034776, -0.0015677346) (-0.00055026384, -0.0015675572) (-0.00055016294, -0.0015673889) (-0.00055004602, -0.0015672312) (-0.00054991421, -0.0015670858) (-0.00054976879, -0.001566954) (-0.00054961114, -0.0015668371) (-0.00054944279, -0.0015667362) (-0.00054926537, -0.0015666522) (-0.00054908057, -0.0015665861) (-0.00054889018, -0.0015665384) (-0.00054869603, -0.0015665096) (-0.0005485, -0.0015665) (-0.0004515, -0.0015665) (-0.00045130397, -0.0015665096) (-0.00045110982, -0.0015665384) (-0.00045091943, -0.0015665861) (-0.00045073463, -0.0015666522) (-0.00045055721, -0.0015667362) (-0.00045038886, -0.0015668371) (-0.00045023121, -0.001566954) (-0.00045008579, -0.0015670858) (-0.00044995398, -0.0015672312) (-0.00044983706, -0.0015673889) (-0.00044973616, -0.0015675572) (-0.00044965224, -0.0015677346) (-0.00044958612, -0.0015679194) (-0.00044953843, -0.0015681098) (-0.00044950963, -0.001568304) (-0.0004495, -0.0015685) (-0.0004495, -0.0016615) (-0.00044950963, -0.001661696) (-0.00044953843, -0.0016618902) (-0.00044958612, -0.0016620806) (-0.00044965224, -0.0016622654) (-0.00044973616, -0.0016624428) (-0.00044983706, -0.0016626111) (-0.00044995398, -0.0016627688) (-0.00045008579, -0.0016629142) (-0.00045023121, -0.001663046) (-0.00045038886, -0.0016631629) (-0.00045055721, -0.0016632638) (-0.00045073463, -0.0016633478) (-0.00045091943, -0.0016634139) (-0.00045110982, -0.0016634616) (-0.00045130397, -0.0016634904) (-0.0004515, -0.0016635) (-0.0005485, -0.0016635), closed, covered)
  tap_trace_n0_ch1 = polyline(z=0, xy: (0.00085, -5e-06) (0.00055, -5e-06) (0.00055, 5e-06) (0.000695, 5e-06) (0.000695, 0.0001) (0.000705, 0.0001) (0.000705, 5e-06) (0.00085, 5e-06) (0.00085, -5e-06), closed, covered)
  tap_cut_n0_ch1 = polyline(z=0, xy: (0.00085, -1.1e-05) (0.00055, -1.1e-05) (0.00055, 1.1e-05) (0.000689, 1.1e-05) (0.000689, 0.0001) (0.000711, 0.0001) (0.000711, 1.1e-05) (0.00085, 1.1e-05) (0.00085, -1.1e-05), closed, covered)
  plate_cp_ch1 = polyline(z=0, xy: (0.0006175, 0.000295) (0.00061753852, 0.00029578414) (0.00061765372, 0.00029656072) (0.00061784448, 0.00029732228) (0.00061810896, 0.00029806147) (0.00061844463, 0.00029877117) (0.00061884824, 0.00029944456) (0.00061931592, 0.00030007515) (0.00061984315, 0.00030065685) (0.00062042485, 0.00030118408) (0.00062105544, 0.00030165176) (0.00062172883, 0.00030205537) (0.00062243853, 0.00030239104) (0.00062317772, 0.00030265552) (0.00062393928, 0.00030284628) (0.00062471586, 0.00030296148) (0.0006255, 0.000303) (0.0007745, 0.000303) (0.00077528414, 0.00030296148) (0.00077606072, 0.00030284628) (0.00077682228, 0.00030265552) (0.00077756147, 0.00030239104) (0.00077827117, 0.00030205537) (0.00077894456, 0.00030165176) (0.00077957515, 0.00030118408) (0.00078015685, 0.00030065685) (0.00078068408, 0.00030007515) (0.00078115176, 0.00029944456) (0.00078155537, 0.00029877117) (0.00078189104, 0.00029806147) (0.00078215552, 0.00029732228) (0.00078234628, 0.00029656072) (0.00078246148, 0.00029578414) (0.0007825, 0.000295) (0.0007825, 0.00027) (0.00078246148, 0.00026921586) (0.00078234628, 0.00026843928) (0.00078215552, 0.00026767772) (0.00078189104, 0.00026693853) (0.00078155537, 0.00026622883) (0.00078115176, 0.00026555544) (0.00078068408, 0.00026492485) (0.00078015685, 0.00026434315) (0.00077957515, 0.00026381592) (0.00077894456, 0.00026334824) (0.00077827117, 0.00026294463) (0.00077756147, 0.00026260896) (0.00077682228, 0.00026234448) (0.00077606072, 0.00026215372) (0.00077528414, 0.00026203852) (0.0007745, 0.000262) (0.0006255, 0.000262) (0.00062471586, 0.00026203852) (0.00062393928, 0.00026215372) (0.00062317772, 0.00026234448) (0.00062243853, 0.00026260896) (0.00062172883, 0.00026294463) (0.00062105544, 0.00026334824) (0.00062042485, 0.00026381592) (0.00061984315, 0.00026434315) (0.00061931592, 0.00026492485) (0.00061884824, 0.00026555544) (0.00061844463, 0.00026622883) (0.00061810896, 0.00026693853) (0.00061784448, 0.00026767772) (0.00061765372, 0.00026843928) (0.00061753852, 0.00026921586) (0.0006175, 0.00027) (0.0006175, 0.000295), closed, covered)
  frame_cp_ch1 = polyline(z=0, xy: (0.0006175, 0.000311) (0.00061671586, 0.00031096148) (0.00061593928, 0.00031084628) (0.00061517772, 0.00031065552) (0.00061443853, 0.00031039104) (0.00061372883, 0.00031005537) (0.00061305544, 0.00030965176) (0.00061242485, 0.00030918408) (0.00061184315, 0.00030865685) (0.00061131592, 0.00030807515) (0.00061084824, 0.00030744456) (0.00061044463, 0.00030677117) (0.00061010896, 0.00030606147) (0.00060984448, 0.00030532228) (0.00060965372, 0.00030456072) (0.00060953852, 0.00030378414) (0.0006095, 0.000303) (0.0006095, 0.000262) (0.00060953852, 0.00026121586) (0.00060965372, 0.00026043928) (0.00060984448, 0.00025967772) (0.00061010896, 0.00025893853) (0.00061044463, 0.00025822883) (0.00061084824, 0.00025755544) (0.00061131592, 0.00025692485) (0.00061184315, 0.00025634315) (0.00061242485, 0.00025581592) (0.00061305544, 0.00025534824) (0.00061372883, 0.00025494463) (0.00061443853, 0.00025460896) (0.00061517772, 0.00025434448) (0.00061593928, 0.00025415372) (0.00061671586, 0.00025403852) (0.0006175, 0.000254) (0.00068090182, 0.000254) (0.00068109806, 0.00025399518) (0.00068158798, 0.00025397111) (0.0006819784, 0.00025393266) (0.00068236646, 0.0002538751) (0.00068275123, 0.00025379856) (0.00068313177, 0.00025370324) (0.00068350719, 0.00025358936) (0.00068387656, 0.0002534572) (0.000684239, 0.00025330707) (0.00068459364, 0.00025313934) (0.00068493962, 0.00025295441) (0.00068527611, 0.00025275272) (0.0006856023, 0.00025253477) (0.0006859174, 0.00025230107) (0.00068622066, 0.0002520522) (0.00068651134, 0.00025178874) (0.00068678874, 0.00025151134) (0.0006870522, 0.00025122066) (0.00068730107, 0.0002509174) (0.00068753477, 0.0002506023) (0.00068775272, 0.00025027611) (0.00068795441, 0.00024993962) (0.00068813934, 0.00024959364) (0.00068830707, 0.000249239) (0.0006884572, 0.00024887656) (0.00068858936, 0.00024850719) (0.00068870324, 0.00024813177) (0.00068879856, 0.00024775123) (0.0006888751, 0.00024736646) (0.00068893266, 0.0002469784) (0.00068897111, 0.00024658799) (0.00068899518, 0.00024609806) (0.000689, 0.00024590182) (0.000689, 0.00019809818) (0.00068899518, 0.00019790194) (0.00068897111, 0.00019741201) (0.00068893266, 0.0001970216) (0.0006888751, 0.00019663354) (0.00068879856, 0.00019624877) (0.00068870324, 0.00019586823) (0.00068858936, 0.00019549281) (0.0006884572, 0.00019512344) (0.00068830707, 0.000194761) (0.00068813934, 0.00019440636) (0.00068795441, 0.00019406038) (0.00068775272, 0.00019372389) (0.00068753477, 0.0001933977) (0.00068730107, 0.00019308259) (0.0006870522, 0.00019277934) (0.00068678874, 0.00019248866) (0.00068651134, 0.00019221126) (0.00068622066, 0.0001919478) (0.0006859174, 0.00019169893) (0.0006856023, 0.00019146523) (0.00068527611, 0.00019124728) (0.00068493962, 0.00019104559) (0.00068459364, 0.00019086066) (0.000684239, 0.00019069293) (0.00068387656, 0.0001905428) (0.00068350719, 0.00019041064) (0.00068313177, 0.00019029676) (0.00068275123, 0.00019020144) (0.00068236646, 0.0001901249) (0.0006819784, 0.00019006734) (0.00068158798, 0.00019002889) (0.00068109806, 0.00019000482) (0.00068090182, 0.00019) (0.00056059818, 0.00019) (0.00056040194, 0.00019000482) (0.00055991202, 0.00019002889) (0.0005595216, 0.00019006734) (0.00055913354, 0.0001901249) (0.00055874877, 0.00019020144) (0.00055836823, 0.00019029676) (0.00055799281, 0.00019041064) (0.00055762344, 0.0001905428) (0.000557261, 0.00019069293) (0.00055690636, 0.00019086066) (0.00055656038, 0.00019104559) (0.00055622389, 0.00019124728) (0.0005558977, 0.00019146523) (0.0005555826, 0.00019169893) (0.00055527934, 0.0001919478) (0.00055498866, 0.00019221126) (0.00055471126, 0.00019248866) (0.0005544478, 0.00019277934) (0.00055419893, 0.00019308259) (0.00055396523, 0.0001933977) (0.00055374728, 0.00019372389) (0.00055354559, 0.00019406038) (0.00055336066, 0.00019440636) (0.00055319293, 0.000194761) (0.0005530428, 0.00019512344) (0.00055291064, 0.00019549281) (0.00055279676, 0.00019586823) (0.00055270144, 0.00019624877) (0.0005526249, 0.00019663354) (0.00055256734, 0.0001970216) (0.00055252889, 0.00019741201) (0.00055250482, 0.00019790194) (0.0005525, 0.00019809818) (0.0005525, 0.00035490182) (0.00055250482, 0.00035509806) (0.00055252889, 0.00035558799) (0.00055256734, 0.0003559784) (0.0005526249, 0.00035636646) (0.00055270144, 0.00035675123) (0.00055279676, 0.00035713177) (0.00055291064, 0.00035750719) (0.0005530428, 0.00035787656) (0.00055319293, 0.000358239) (0.00055336066, 0.00035859364) (0.00055354559, 0.00035893962) (0.00055374728, 0.00035927611) (0.00055396523, 0.0003596023) (0.00055419893, 0.00035991741) (0.0005544478, 0.00036022066) (0.00055471126, 0.00036051134) (0.00055498866, 0.00036078874) (0.00055527934, 0.0003610522) (0.0005555826, 0.00036130107) (0.0005558977, 0.00036153477) (0.00055622389, 0.00036175272) (0.00055656038, 0.00036195441) (0.00055690636, 0.00036213934) (0.000557261, 0.00036230707) (0.00055762344, 0.0003624572) (0.00055799281, 0.00036258936) (0.00055836823, 0.00036270324) (0.00055874877, 0.00036279856) (0.00055913354, 0.0003628751) (0.0005595216, 0.00036293266) (0.00055991202, 0.00036297111) (0.00056040194, 0.00036299518) (0.00056059818, 0.000363) (0.00083940182, 0.000363) (0.00083959806, 0.00036299518) (0.00084008798, 0.00036297111) (0.0008404784, 0.00036293266) (0.00084086646, 0.0003628751) (0.00084125123, 0.00036279856) (0.00084163177, 0.00036270324) (0.00084200719, 0.00036258936) (0.00084237656, 0.0003624572) (0.000842739, 0.00036230707) (0.00084309364, 0.00036213934) (0.00084343962, 0.00036195441) (0.00084377611, 0.00036175272) (0.0008441023, 0.00036153477) (0.0008444174, 0.00036130107) (0.00084472066, 0.0003610522) (0.00084501134, 0.00036078874) (0.00084528874, 0.00036051134) (0.0008455522, 0.00036022066) (0.00084580107, 0.00035991741) (0.00084603477, 0.0003596023) (0.00084625272, 0.00035927611) (0.00084645441, 0.00035893962) (0.00084663934, 0.00035859364) (0.00084680707, 0.000358239) (0.0008469572, 0.00035787656) (0.00084708936, 0.00035750719) (0.00084720324, 0.00035713177) (0.00084729856, 0.00035675123) (0.0008473751, 0.00035636646) (0.00084743266, 0.0003559784) (0.00084747111, 0.00035558799) (0.00084749518, 0.00035509806) (0.0008475, 0.00035490182) (0.0008475, 0.00019809818) (0.00084749518, 0.00019790194) (0.00084747111, 0.00019741201) (0.00084743266, 0.0001970216) (0.0008473751, 0.00019663354) (0.00084729856, 0.00019624877) (0.00084720324, 0.00019586823) (0.00084708936, 0.00019549281) (0.0008469572, 0.00019512344) (0.00084680707, 0.000194761) (0.00084663934, 0.00019440636) (0.00084645441, 0.00019406038) (0.00084625272, 0.00019372389) (0.00084603477, 0.0001933977) (0.00084580107, 0.00019308259) (0.0008455522, 0.00019277934) (0.00084528874, 0.00019248866) (0.00084501134, 0.00019221126) (0.00084472066, 0.0001919478) (0.0008444174, 0.00019169893) (0.0008441023, 0.00019146523) (0.00084377611, 0.00019124728) (0.00084343962, 0.00019104559) (0.00084309364, 0.00019086066) (0.000842739, 0.00019069293) (0.00084237656, 0.0001905428) (0.00084200719, 0.00019041064) (0.00084163177, 0.00019029676) (0.00084125123, 0.00019020144) (0.00084086646, 0.0001901249) (0.0008404784, 0.00019006734) (0.00084008798, 0.00019002889) (0.00083959806, 0.00019000482) (0.00083940182, 0.00019) (0.00071909818, 0.00019) (0.00071890194, 0.00019000482) (0.00071841202, 0.00019002889) (0.0007180216, 0.00019006734) (0.00071763354, 0.0001901249) (0.00071724877, 0.00019020144) (0.00071686823, 0.00019029676) (0.00071649281, 0.00019041064) (0.00071612344, 0.0001905428) (0.000715761, 0.00019069293) (0.00071540636, 0.00019086066) (0.00071506038, 0.00019104559) (0.00071472389, 0.00019124728) (0.0007143977, 0.00019146523) (0.0007140826, 0.00019169893) (0.00071377934, 0.0001919478) (0.00071348866, 0.00019221126) (0.00071321126, 0.00019248866) (0.0007129478, 0.00019277934) (0.00071269893, 0.00019308259) (0.00071246523, 0.0001933977) (0.00071224728, 0.00019372389) (0.00071204559, 0.00019406038) (0.00071186066, 0.00019440636) (0.00071169293, 0.000194761) (0.0007115428, 0.00019512344) (0.00071141064, 0.00019549281) (0.00071129676, 0.00019586823) (0.00071120144, 0.00019624877) (0.0007111249, 0.00019663354) (0.00071106734, 0.0001970216) (0.00071102889, 0.00019741201) (0.00071100482, 0.00019790194) (0.000711, 0.00019809818) (0.000711, 0.00024590182) (0.00071100482, 0.00024609806) (0.00071102889, 0.00024658799) (0.00071106734, 0.0002469784) (0.0007111249, 0.00024736646) (0.00071120144, 0.00024775123) (0.00071129676, 0.00024813177) (0.00071141064, 0.00024850719) (0.0007115428, 0.00024887656) (0.00071169293, 0.000249239) (0.00071186066, 0.00024959364) (0.00071204559, 0.00024993962) (0.00071224728, 0.00025027611) (0.00071246523, 0.0002506023) (0.00071269893, 0.0002509174) (0.0007129478, 0.00025122066) (0.00071321126, 0.00025151134) (0.00071348866, 0.00025178874) (0.00071377934, 0.0002520522) (0.0007140826, 0.00025230107) (0.0007143977, 0.00025253477) (0.00071472389, 0.00025275272) (0.00071506038, 0.00025295441) (0.00071540636, 0.00025313934) (0.000715761, 0.00025330707) (0.00071612344, 0.0002534572) (0.00071649281, 0.00025358936) (0.00071686823, 0.00025370324)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, closed, covered)
  pocket_cp_ch1 = polyline(z=0, xy: (0.0005525, 0.000375) (0.0008475, 0.000375) (0.00084867621, 0.00037494222) (0.00084984108, 0.00037476942) (0.00085098342, 0.00037448328) (0.0008520922, 0.00037408655) (0.00085315676, 0.00037358305) (0.00085416684, 0.00037297763) (0.00085511272, 0.00037227612) (0.00085598528, 0.00037148528) (0.00085677612, 0.00037061272) (0.00085747764, 0.00036966684) (0.00085808306, 0.00036865676) (0.00085858655, 0.0003675922) (0.00085898328, 0.00036648342) (0.00085926942, 0.00036534108) (0.00085944222, 0.00036417621) (0.0008595, 0.000363) (0.0008595, 0.00019) (0.00085944222, 0.00018882379) (0.00085926942, 0.00018765892) (0.00085898328, 0.00018651658) (0.00085858655, 0.0001854078) (0.00085808306, 0.00018434324) (0.00085747764, 0.00018333316) (0.00085677612, 0.00018238728) (0.00085598528, 0.00018151472) (0.00085511272, 0.00018072388) (0.00085416684, 0.00018002237) (0.00085315676, 0.00017941694) (0.0008520922, 0.00017891345) (0.00085098342, 0.00017851672) (0.00084984108, 0.00017823058) (0.00084867621, 0.00017805778) (0.0008475, 0.000178) (0.0005525, 0.000178) (0.00055132379, 0.00017805778) (0.00055015892, 0.00017823058) (0.00054901658, 0.00017851672) (0.0005479078, 0.00017891345) (0.00054684324, 0.00017941694) (0.00054583316, 0.00018002237) (0.00054488728, 0.00018072388) (0.00054401472, 0.00018151472) (0.00054322387, 0.00018238728) (0.00054252236, 0.00018333316) (0.00054191695, 0.00018434324) (0.00054141345, 0.0001854078) (0.00054101672, 0.00018651658) (0.00054073058, 0.00018765892) (0.00054055778, 0.00018882379) (0.0005405, 0.00019) (0.0005405, 0.000363) (0.00054055778, 0.00036417621) (0.00054073058, 0.00036534108) (0.00054101672, 0.00036648342) (0.00054141345, 0.0003675922) (0.00054191695, 0.00036865676) (0.00054252236, 0.00036966684) (0.00054322387, 0.00037061272) (0.00054401472, 0.00037148528) (0.00054488728, 0.00037227612) (0.00054583316, 0.00037297763) (0.00054684324, 0.00037358305) (0.0005479078, 0.00037408655) (0.00054901658, 0.00037448328) (0.00055015892, 0.00037476942) (0.00055132379, 0.00037494222) (0.0005525, 0.000375), closed, covered)
  tap_trace_jf_ch1 = polyline(z=0, xy: (0.000695, 0.001465) (0.000695, 0.001765) (0.000705, 0.001765) (0.000705, 0.00162) (0.0007355, 0.00162) (0.0007355, 0.00161) (0.000705, 0.00161) (0.000705, 0.001465) (0.000695, 0.001465), closed, covered)
  tap_cut_jf_ch1 = polyline(z=0, xy: (0.000689, 0.001465) (0.000689, 0.001765) (0.000711, 0.001765) (0.000711, 0.001626) (0.0007355, 0.001626) (0.0007355, 0.001604) (0.000711, 0.001604) (0.000711, 0.001465) (0.000689, 0.001465), closed, covered)
  tap_trace_jr_ch1 = polyline(z=0, xy: (0.0008645, 0.00162) (0.000895, 0.00162) (0.000895, 0.001765) (0.000905, 0.001765) (0.000905, 0.001465) (0.000895, 0.001465) (0.000895, 0.00161) (0.0008645, 0.00161) (0.0008645, 0.00162), closed, covered)
  tap_cut_jr_ch1 = polyline(z=0, xy: (0.0008645, 0.001626) (0.000889, 0.001626) (0.000889, 0.001765) (0.000911, 0.001765) (0.000911, 0.001465) (0.000889, 0.001465) (0.000889, 0.001604) (0.0008645, 0.001604) (0.0008645, 0.001626), closed, covered)
  head_a_cj_ch1 = polyline(z=0, xy: (0.0007675, 0.0015825) (0.00076730397, 0.0015825096) (0.00076710982, 0.0015825384) (0.00076691943, 0.0015825861) (0.00076673463, 0.0015826522) (0.00076655721, 0.0015827362) (0.00076638886, 0.0015828371) (0.00076623121, 0.001582954) (0.00076608579, 0.0015830858) (0.00076595398, 0.0015832312) (0.00076583706, 0.0015833889) (0.00076573616, 0.0015835572) (0.00076565224, 0.0015837346) (0.00076558612, 0.0015839194) (0.00076553843, 0.0015841098) (0.00076550963, 0.001584304) (0.0007655, 0.0015845) (0.0007655, 0.0016455) (0.00076550963, 0.001645696) (0.00076553843, 0.0016458902) (0.00076558612, 0.0016460806) (0.00076565224, 0.0016462654) (0.00076573616, 0.0016464428) (0.00076583706, 0.0016466111) (0.00076595398, 0.0016467688) (0.00076608579, 0.0016469142) (0.00076623121, 0.001647046) (0.00076638886, 0.0016471629) (0.00076655721, 0.0016472638) (0.00076673463, 0.0016473478) (0.00076691943, 0.0016474139) (0.00076710982, 0.0016474616) (0.00076730397, 0.0016474904) (0.0007675, 0.0016475) (0.0007885, 0.0016475) (0.00078869603, 0.0016474904) (0.00078889018, 0.0016474616) (0.00078908057, 0.0016474139) (0.00078926537, 0.0016473478) (0.00078944279, 0.0016472638) (0.00078961114, 0.0016471629) (0.00078976879, 0.001647046) (0.00078991421, 0.0016469142) (0.00079004602, 0.0016467688) (0.00079016294, 0.0016466111) (0.00079026384, 0.0016464428) (0.00079034776, 0.0016462654) (0.00079041388, 0.0016460806) (0.00079046157, 0.0016458902) (0.00079049037, 0.001645696) (0.0007905, 0.0016455) (0.0007905, 0.0015845) (0.00079049037, 0.001584304) (0.00079046157, 0.0015841098) (0.00079041388, 0.0015839194) (0.00079034776, 0.0015837346) (0.00079026384, 0.0015835572) (0.00079016294, 0.0015833889) (0.00079004602, 0.0015832312) (0.00078991421, 0.0015830858) (0.00078976879, 0.001582954) (0.00078961114, 0.0015828371) (0.00078944279, 0.0015827362) (0.00078926537, 0.0015826522) (0.00078908057, 0.0015825861) (0.00078889018, 0.0015825384) (0.00078869603, 0.0015825096) (0.0007885, 0.0015825) (0.0007675, 0.0015825), closed, covered)
  head_b_cj_ch1 = polyline(z=0, xy: (0.0008115, 0.0015825) (0.00081130397, 0.0015825096) (0.00081110982, 0.0015825384) (0.00081091943, 0.0015825861) (0.00081073463, 0.0015826522) (0.00081055721, 0.0015827362) (0.00081038886, 0.0015828371) (0.00081023121, 0.001582954) (0.00081008579, 0.0015830858) (0.00080995398, 0.0015832312) (0.00080983706, 0.0015833889) (0.00080973616, 0.0015835572) (0.00080965224, 0.0015837346) (0.00080958612, 0.0015839194) (0.00080953843, 0.0015841098) (0.00080950963, 0.001584304) (0.0008095, 0.0015845) (0.0008095, 0.0016455) (0.00080950963, 0.001645696) (0.00080953843, 0.0016458902) (0.00080958612, 0.0016460806) (0.00080965224, 0.0016462654) (0.00080973616, 0.0016464428) (0.00080983706, 0.0016466111) (0.00080995398, 0.0016467688) (0.00081008579, 0.0016469142) (0.00081023121, 0.001647046) (0.00081038886, 0.0016471629) (0.00081055721, 0.0016472638) (0.00081073463, 0.0016473478) (0.00081091943, 0.0016474139) (0.00081110982, 0.0016474616) (0.00081130397, 0.0016474904) (0.0008115, 0.0016475) (0.0008325, 0.0016475) (0.00083269603, 0.0016474904) (0.00083289018, 0.0016474616) (0.00083308057, 0.0016474139) (0.00083326537, 0.0016473478) (0.00083344279, 0.0016472638) (0.00083361114, 0.0016471629) (0.00083376879, 0.001647046) (0.00083391421, 0.0016469142) (0.00083404602, 0.0016467688) (0.00083416294, 0.0016466111) (0.00083426384, 0.0016464428) (0.00083434776, 0.0016462654) (0.00083441388, 0.0016460806) (0.00083446157, 0.0016458902) (0.00083449037, 0.001645696) (0.0008345, 0.0016455) (0.0008345, 0.0015845) (0.00083449037, 0.001584304) (0.00083446157, 0.0015841098) (0.00083441388, 0.0015839194) (0.00083434776, 0.0015837346) (0.00083426384, 0.0015835572) (0.00083416294, 0.0015833889) (0.00083404602, 0.0015832312) (0.00083391421, 0.0015830858) (0.00083376879, 0.001582954) (0.00083361114, 0.0015828371) (0.00083344279, 0.0015827362) (0.00083326537, 0.0015826522) (0.00083308057, 0.0015825861) (0.00083289018, 0.0015825384) (0.00083269603, 0.0015825096) (0.0008325, 0.0015825) (0.0008115, 0.0015825), closed, covered)
  pocket_cj_ch1 = polyline(z=0, xy: (0.0007515, 0.0015665) (0.00075130397, 0.0015665096) (0.00075110982, 0.0015665384) (0.00075091943, 0.0015665861) (0.00075073463, 0.0015666522) (0.00075055721, 0.0015667362) (0.00075038886, 0.0015668371) (0.00075023121, 0.001566954) (0.00075008579, 0.0015670858) (0.00074995398, 0.0015672312) (0.00074983706, 0.0015673889) (0.00074973616, 0.0015675572) (0.00074965224, 0.0015677346) (0.00074958612, 0.0015679194) (0.00074953843, 0.0015681098) (0.00074950963, 0.001568304) (0.0007495, 0.0015685) (0.0007495, 0.0016615) (0.00074950963, 0.001661696) (0.00074953843, 0.0016618902) (0.00074958612, 0.0016620806) (0.00074965224, 0.0016622654) (0.00074973616, 0.0016624428) (0.00074983706, 0.0016626111) (0.00074995398, 0.0016627688) (0.00075008579, 0.0016629142) (0.00075023121, 0.001663046) (0.00075038886, 0.0016631629) (0.00075055721, 0.0016632638) (0.00075073463, 0.0016633478) (0.00075091943, 0.0016634139) (0.00075110982, 0.0016634616) (0.00075130397, 0.0016634904) (0.0007515, 0.0016635) (0.0008485, 0.0016635) (0.00084869603, 0.0016634904) (0.00084889018, 0.0016634616) (0.00084908057, 0.0016634139) (0.00084926537, 0.0016633478) (0.00084944279, 0.0016632638) (0.00084961114, 0.0016631629) (0.00084976879, 0.001663046) (0.00084991421, 0.0016629142) (0.00085004602, 0.0016627688) (0.00085016294, 0.0016626111) (0.00085026384, 0.0016624428) (0.00085034776, 0.0016622654) (0.00085041388, 0.0016620806) (0.00085046157, 0.0016618902) (0.00085049037, 0.001661696) (0.0008505, 0.0016615) (0.0008505, 0.0015685) (0.00085049037, 0.001568304) (0.00085046157, 0.0015681098) (0.00085041388, 0.0015679194) (0.00085034776, 0.0015677346) (0.00085026384, 0.0015675572) (0.00085016294, 0.0015673889) (0.00085004602, 0.0015672312) (0.00084991421, 0.0015670858) (0.00084976879, 0.001566954) (0.00084961114, 0.0015668371) (0.00084944279, 0.0015667362) (0.00084926537, 0.0015666522) (0.00084908057, 0.0015665861) (0.00084889018, 0.0015665384) (0.00084869603, 0.0015665096) (0.0008485, 0.0015665) (0.0007515, 0.0015665), closed, covered)
  tap_trace_n0_ch3 = polyline(z=0, xy: (0.001995, -0.0001) (0.001995, -5e-06) (0.00185, -5e-06) (0.00185, 5e-06) (0.00215, 5e-06) (0.00215, -5e-06) (0.002005, -5e-06) (0.002005, -0.0001) (0.001995, -0.0001), closed, covered)
  tap_cut_n0_ch3 = polyline(z=0, xy: (0.001989, -0.0001) (0.001989, -1.1e-05) (0.00185, -1.1e-05) (0.00185, 1.1e-05) (0.00215, 1.1e-05) (0.00215, -1.1e-05) (0.002011, -1.1e-05) (0.002011, -0.0001) (0.001989, -0.0001), closed, covered)
  plate_cp_ch3 = polyline(z=0, xy: (0.0020825, -0.000295) (0.0020824615, -0.00029578414) (0.0020823463, -0.00029656072) (0.0020821555, -0.00029732228) (0.002081891, -0.00029806147) (0.0020815554, -0.00029877117) (0.0020811518, -0.00029944456) (0.0020806841, -0.00030007515) (0.0020801569, -0.00030065685) (0.0020795751, -0.00030118408) (0.0020789446, -0.00030165176) (0.0020782712, -0.00030205537) (0.0020775615, -0.00030239104) (0.0020768223, -0.00030265552) (0.0020760607, -0.00030284628) (0.0020752841, -0.00030296148) (0.0020745, -0.000303) (0.0019255, -0.000303) (0.0019247159, -0.00030296148) (0.0019239393, -0.00030284628) (0.0019231777, -0.00030265552) (0.0019224385, -0.00030239104) (0.0019217288, -0.00030205537) (0.0019210554, -0.00030165176) (0.0019204249, -0.00030118408) (0.0019198431, -0.00030065685) (0.0019193159, -0.00030007515) (0.0019188482, -0.00029944456) (0.0019184446, -0.00029877117) (0.001918109, -0.00029806147) (0.0019178445, -0.00029732228) (0.0019176537, -0.00029656072) (0.0019175385, -0.00029578414) (0.0019175, -0.000295) (0.0019175, -0.00027) (0.0019175385, -0.00026921586) (0.0019176537, -0.00026843928) (0.0019178445, -0.00026767772) (0.001918109, -0.00026693853) (0.0019184446, -0.00026622883) (0.0019188482, -0.00026555544) (0.0019193159, -0.00026492485) (0.0019198431, -0.00026434315) (0.0019204249, -0.00026381592) (0.0019210554, -0.00026334824) (0.0019217288, -0.00026294463) (0.0019224385, -0.00026260896) (0.0019231777, -0.00026234448) (0.0019239393, -0.00026215372) (0.0019247159, -0.00026203852) (0.0019255, -0.000262) (0.0020745, -0.000262) (0.0020752841, -0.00026203852) (0.0020760607, -0.00026215372) (0.0020768223, -0.00026234448) (0.0020775615, -0.00026260896) (0.0020782712, -0.00026294463) (0.0020789446, -0.00026334824) (0.0020795751, -0.00026381592) (0.0020801569, -0.00026434315) (0.0020806841, -0.00026492485) (0.0020811518, -0.00026555544) (0.0020815554, -0.00026622883) (0.002081891, -0.00026693853) (0.0020821555, -0.00026767772) (0.0020823463, -0.00026843928) (0.0020824615, -0.00026921586) (0.0020825, -0.00027) (0.0020825, -0.000295), closed, covered)
  frame_cp_ch3 = polyline(z=0, xy: (0.0020825, -0.000311) (0.0020832841, -0.00031096148) (0.0020840607, -0.00031084628) (0.0020848223, -0.00031065552) (0.0020855615, -0.00031039104) (0.0020862712, -0.00031005537) (0.0020869446, -0.00030965176) (0.0020875751, -0.00030918408) (0.0020881569, -0.00030865685) (0.0020886841, -0.00030807515) (0.0020891518, -0.00030744456) (0.0020895554, -0.00030677117) (0.002089891, -0.00030606147) (0.0020901555, -0.00030532228) (0.0020903463, -0.00030456072) (0.0020904615, -0.00030378414) (0.0020905, -0.000303) (0.0020905, -0.000262) (0.0020904615, -0.00026121586) (0.0020903463, -0.00026043928) (0.0020901555, -0.00025967772) (0.002089891, -0.00025893853) (0.0020895554, -0.00025822883) (0.0020891518, -0.00025755544) (0.0020886841, -0.00025692485) (0.0020881569, -0.00025634315) (0.0020875751, -0.00025581592) (0.0020869446, -0.00025534824) (0.0020862712, -0.00025494463) (0.0020855615, -0.00025460896) (0.0020848223, -0.00025434448) (0.0020840607, -0.00025415372) (0.0020832841, -0.00025403852) (0.0020825, -0.000254) (0.0020190982, -0.000254) (0.0020189019, -0.00025399518) (0.002018412, -0.00025397111) (0.0020180216, -0.00025393266) (0.0020176335, -0.0002538751) (0.0020172488, -0.00025379856) (0.0020168682, -0.00025370324) (0.0020164928, -0.00025358936) (0.0020161234, -0.0002534572) (0.002015761, -0.00025330707) (0.0020154064, -0.00025313934) (0.0020150604, -0.00025295441) (0.0020147239, -0.00025275272) (0.0020143977, -0.00025253477) (0.0020140826, -0.00025230107) (0.0020137793, -0.0002520522) (0.0020134887, -0.00025178874) (0.0020132113, -0.00025151134) (0.0020129478, -0.00025122066) (0.0020126989, -0.0002509174) (0.0020124652, -0.0002506023) (0.0020122473, -0.00025027611) (0.0020120456, -0.00024993962) (0.0020118607, -0.00024959364) (0.0020116929, -0.000249239) (0.0020115428, -0.00024887656) (0.0020114106, -0.00024850719) (0.0020112968, -0.00024813177) (0.0020112014, -0.00024775123) (0.0020111249, -0.00024736646) (0.0020110673, -0.0002469784) (0.0020110289, -0.00024658799) (0.0020110048, -0.00024609806) (0.002011, -0.00024590182) (0.002011, -0.00019809818) (0.0020110048, -0.00019790194) (0.0020110289, -0.00019741201) (0.0020110673, -0.0001970216) (0.0020111249, -0.00019663354) (0.0020112014, -0.00019624877) (0.0020112968, -0.00019586823) (0.0020114106, -0.00019549281) (0.0020115428, -0.00019512344) (0.0020116929, -0.000194761) (0.0020118607, -0.00019440636) (0.0020120456, -0.00019406038) (0.0020122473, -0.00019372389) (0.0020124652, -0.0001933977) (0.0020126989, -0.00019308259) (0.0020129478, -0.00019277934) (0.0020132113, -0.00019248866) (0.0020134887, -0.00019221126) (0.0020137793, -0.0001919478) (0.0020140826, -0.00019169893) (0.0020143977, -0.00019146523) (0.0020147239, -0.00019124728) (0.0020150604, -0.00019104559) (0.0020154064, -0.00019086066) (0.002015761, -0.00019069293) (0.0020161234, -0.0001905428) (0.0020164928, -0.00019041064) (0.0020168682, -0.00019029676) (0.0020172488, -0.00019020144) (0.0020176335, -0.0001901249) (0.0020180216, -0.00019006734) (0.002018412, -0.00019002889) (0.0020189019, -0.00019000482) (0.0020190982, -0.00019) (0.0021394018, -0.00019) (0.0021395981, -0.00019000482) (0.002140088, -0.00019002889) (0.0021404784, -0.00019006734) (0.0021408665, -0.0001901249) (0.0021412512, -0.00019020144) (0.0021416318, -0.00019029676) (0.0021420072, -0.00019041064) (0.0021423766, -0.0001905428) (0.002142739, -0.00019069293) (0.0021430936, -0.00019086066) (0.0021434396, -0.00019104559) (0.0021437761, -0.00019124728) (0.0021441023, -0.00019146523) (0.0021444174, -0.00019169893) (0.0021447207, -0.0001919478) (0.0021450113, -0.00019221126) (0.0021452887, -0.00019248866) (0.0021455522, -0.00019277934) (0.0021458011, -0.00019308259) (0.0021460348, -0.0001933977) (0.0021462527, -0.00019372389) (0.0021464544, -0.00019406038) (0.0021466393, -0.00019440636) (0.0021468071, -0.000194761) (0.0021469572, -0.00019512344) (0.0021470894, -0.00019549281) (0.0021472032, -0.00019586823) (0.0021472986, -0.00019624877) (0.0021473751, -0.00019663354) (0.0021474327, -0.0001970216) (0.0021474711, -0.00019741201) (0.0021474952, -0.00019790194) (0.0021475, -0.00019809818) (0.0021475, -0.00035490182) (0.0021474952, -0.00035509806) (0.0021474711, -0.00035558799) (0.0021474327, -0.0003559784) (0.0021473751, -0.00035636646) (0.0021472986, -0.00035675123) (0.0021472032, -0.00035713177) (0.0021470894, -0.00035750719) (0.0021469572, -0.00035787656) (0.0021468071, -0.000358239) (0.0021466393, -0.00035859364) (0.0021464544, -0.00035893962) (0.0021462527, -0.00035927611) (0.0021460348, -0.0003596023) (0.0021458011, -0.00035991741) (0.0021455522, -0.00036022066) (0.0021452887, -0.00036051134) (0.0021450113, -0.00036078874) (0.0021447207, -0.0003610522) (0.0021444174, -0.00036130107) (0.0021441023, -0.00036153477) (0.0021437761, -0.00036175272) (0.0021434396, -0.00036195441) (0.0021430936, -0.00036213934) (0.002142739, -0.00036230707) (0.0021423766, -0.0003624572) (0.0021420072, -0.00036258936) (0.0021416318, -0.00036270324) (0.0021412512, -0.00036279856) (0.0021408665, -0.0003628751) (0.0021404784, -0.00036293266) (0.002140088, -0.00036297111) (0.0021395981, -0.00036299518) (0.0021394018, -0.000363) (0.0018605982, -0.000363) (0.0018604019, -0.00036299518) (0.001859912, -0.00036297111) (0.0018595216, -0.00036293266) (0.0018591335, -0.0003628751) (0.0018587488, -0.00036279856) (0.0018583682, -0.00036270324) (0.0018579928, -0.00036258936) (0.0018576234, -0.0003624572) (0.001857261, -0.00036230707) (0.0018569064, -0.00036213934) (0.0018565604, -0.00036195441) (0.0018562239, -0.00036175272) (0.0018558977, -0.00036153477) (0.0018555826, -0.00036130107) (0.0018552793, -0.0003610522) (0.0018549887, -0.00036078874) (0.0018547113, -0.00036051134) (0.0018544478, -0.00036022066) (0.0018541989, -0.00035991741) (0.0018539652, -0.0003596023) (0.0018537473, -0.00035927611) (0.0018535456, -0.00035893962) (0.0018533607, -0.00035859364) (0.0018531929, -0.000358239) (0.0018530428, -0.00035787656) (0.0018529106, -0.00035750719) (0.0018527968, -0.00035713177) (0.0018527014, -0.00035675123) (0.0018526249, -0.00035636646) (0.0018525673, -0.0003559784) (0.0018525289, -0.00035558799) (0.0018525048, -0.00035509806) (0.0018525, -0.00035490182) (0.0018525, -0.00019809818) (0.0018525048, -0.00019790194) (0.0018525289, -0.00019741201) (0.0018525673, -0.0001970216) (0.0018526249, -0.00019663354) (0.0018527014, -0.00019624877) (0.0018527968, -0.00019586823) (0.0018529106, -0.00019549281) (0.0018530428, -0.00019512344) (0.0018531929, -0.000194761) (0.0018533607, -0.00019440636) (0.0018535456, -0.00019406038) (0.0018537473, -0.00019372389) (0.0018539652, -0.0001933977) (0.0018541989, -0.00019308259) (0.0018544478, -0.00019277934) (0.0018547113, -0.00019248866) (0.0018549887, -0.00019221126) (0.0018552793, -0.0001919478) (0.0018555826, -0.00019169893) (0.0018558977, -0.00019146523) (0.0018562239, -0.00019124728) (0.0018565604, -0.00019104559) (0.0018569064, -0.00019086066) (0.001857261, -0.00019069293) (0.0018576234, -0.0001905428) (0.0018579928, -0.00019041064) (0.0018583682, -0.00019029676) (0.0018587488, -0.00019020144) (0.0018591335, -0.0001901249) (0.0018595216, -0.00019006734) (0.001859912, -0.00019002889) (0.0018604019, -0.00019000482) (0.0018605982, -0.00019) (0.0019809018, -0.00019) (0.0019810981, -0.00019000482) (0.001981588, -0.00019002889) (0.0019819784, -0.00019006734) (0.0019823665, -0.0001901249) (0.0019827512, -0.00019020144) (0.0019831318, -0.00019029676) (0.0019835072, -0.00019041064) (0.0019838766, -0.0001905428) (0.001984239, -0.00019069293) (0.0019845936, -0.00019086066) (0.0019849396, -0.00019104559) (0.0019852761, -0.00019124728) (0.0019856023, -0.00019146523) (0.0019859174, -0.00019169893) (0.0019862207, -0.0001919478) (0.0019865113, -0.00019221126) (0.0019867887, -0.00019248866) (0.0019870522, -0.00019277934) (0.0019873011, -0.00019308259) (0.0019875348, -0.0001933977) (0.0019877527, -0.00019372389) (0.0019879544, -0.00019406038) (0.0019881393, -0.00019440636) (0.0019883071, -0.000194761) (0.0019884572, -0.00019512344) (0.0019885894, -0.00019549281) (0.0019887032, -0.00019586823) (0.0019887986, -0.00019624877) (0.0019888751, -0.00019663354) (0.0019889327, -0.0001970216) (0.0019889711, -0.00019741201) (0.0019889952, -0.00019790194) (0.001989, -0.00019809818) (0.001989, -0.00024590182) (0.0019889952, -0.00024609806) (0.0019889711, -0.00024658799) (0.0019889327, -0.0002469784) (0.0019888751, -0.00024736646) (0.0019887986, -0.00024775123) (0.0019887032, -0.00024813177) (0.0019885894, -0.00024850719) (0.0019884572, -0.00024887656) (0.0019883071, -0.000249239) (0.0019881393, -0.00024959364) (0.0019879544, -0.00024993962) (0.0019877527, -0.00025027611) (0.0019875348, -0.0002506023) (0.0019873011, -0.0002509174) (0.0019870522, -0.00025122066) (0.0019867887, -0.00025151134) (0.0019865113, -0.00025178874) (0.0019862207, -0.0002520522) (0.0019859174, -0.00025230107) (0.0019856023, -0.00025253477) (0.0019852761, -0.00025275272) (0.0019849396, -0.00025295441) (0.0019845936, -0.00025313934) (0.001984239, -0.00025330707) (0.0019838766, -0.0002534572) (0.0019835072, -0.00025358936) (0.0019831318, -0.00025370324)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, closed, covered)
  pocket_cp_ch3 = polyline(z=0, xy: (0.0021475, -0.000375) (0.0018525, -0.000375) (0.0018513238, -0.00037494222) (0.0018501589, -0.00037476942) (0.0018490166, -0.00037448328) (0.0018479078, -0.00037408655) (0.0018468432, -0.00037358305) (0.0018458332, -0.00037297763) (0.0018448873, -0.00037227612) (0.0018440147, -0.00037148528) (0.0018432239, -0.00037061272) (0.0018425224, -0.00036966684) (0.0018419169, -0.00036865676) (0.0018414134, -0.0003675922) (0.0018410167, -0.00036648342) (0.0018407306, -0.00036534108) (0.0018405578, -0.00036417621) (0.0018405, -0.000363) (0.0018405, -0.00019) (0.0018405578, -0.00018882379) (0.0018407306, -0.00018765892) (0.0018410167, -0.00018651658) (0.0018414134, -0.0001854078) (0.0018419169, -0.00018434324) (0.0018425224, -0.00018333316) (0.0018432239, -0.00018238728) (0.0018440147, -0.00018151472) (0.0018448873, -0.00018072388) (0.0018458332, -0.00018002237) (0.0018468432, -0.00017941694) (0.0018479078, -0.00017891345) (0.0018490166, -0.00017851672) (0.0018501589, -0.00017823058) (0.0018513238, -0.00017805778) (0.0018525, -0.000178) (0.0021475, -0.000178) (0.0021486762, -0.00017805778) (0.0021498411, -0.00017823058) (0.0021509834, -0.00017851672) (0.0021520922, -0.00017891345) (0.0021531568, -0.00017941694) (0.0021541668, -0.00018002237) (0.0021551127, -0.00018072388) (0.0021559853, -0.00018151472) (0.0021567761, -0.00018238728) (0.0021574776, -0.00018333316) (0.0021580831, -0.00018434324) (0.0021585866, -0.0001854078) (0.0021589833, -0.00018651658) (0.0021592694, -0.00018765892) (0.0021594422, -0.00018882379) (0.0021595, -0.00019) (0.0021595, -0.000363) (0.0021594422, -0.00036417621) (0.0021592694, -0.00036534108) (0.0021589833, -0.00036648342) (0.0021585866, -0.0003675922) (0.0021580831, -0.00036865676) (0.0021574776, -0.00036966684) (0.0021567761, -0.00037061272) (0.0021559853, -0.00037148528) (0.0021551127, -0.00037227612) (0.0021541668, -0.00037297763) (0.0021531568, -0.00037358305) (0.0021520922, -0.00037408655) (0.0021509834, -0.00037448328) (0.0021498411, -0.00037476942) (0.0021486762, -0.00037494222) (0.0021475, -0.000375), closed, covered)
  tap_trace_jf_ch3 = polyline(z=0, xy: (0.002005, -0.001465) (0.002005, -0.00161) (0.0020355, -0.00161) (0.0020355, -0.00162) (0.002005, -0.00162) (0.002005, -0.001765) (0.001995, -0.001765) (0.001995, -0.001465) (0.002005, -0.001465), closed, covered)
  tap_cut_jf_ch3 = polyline(z=0, xy: (0.002011, -0.001465) (0.002011, -0.001604) (0.0020355, -0.001604) (0.0020355, -0.001626) (0.002011, -0.001626) (0.002011, -0.001765) (0.001989, -0.001765) (0.001989, -0.001465) (0.002011, -0.001465), closed, covered)
  tap_trace_jr_ch3 = polyline(z=0, xy: (0.0021645, -0.00161) (0.002195, -0.00161) (0.002195, -0.001465) (0.002205, -0.001465) (0.002205, -0.001765) (0.002195, -0.001765) (0.002195, -0.00162) (0.0021645, -0.00162) (0.0021645, -0.00161), closed, covered)
  tap_cut_jr_ch3 = polyline(z=0, xy: (0.0021645, -0.001604) (0.002189, -0.001604) (0.002189, -0.001465) (0.002211, -0.001465) (0.002211, -0.001765) (0.002189, -0.001765) (0.002189, -0.001626) (0.0021645, -0.001626) (0.0021645, -0.001604), closed, covered)
  head_a_cj_ch3 = polyline(z=0, xy: (0.0020675, -0.0016475) (0.002067304, -0.0016474904) (0.0020671098, -0.0016474616) (0.0020669194, -0.0016474139) (0.0020667346, -0.0016473478) (0.0020665572, -0.0016472638) (0.0020663889, -0.0016471629) (0.0020662312, -0.001647046) (0.0020660858, -0.0016469142) (0.002065954, -0.0016467688) (0.0020658371, -0.0016466111) (0.0020657362, -0.0016464428) (0.0020656522, -0.0016462654) (0.0020655861, -0.0016460806) (0.0020655384, -0.0016458902) (0.0020655096, -0.001645696) (0.0020655, -0.0016455) (0.0020655, -0.0015845) (0.0020655096, -0.001584304) (0.0020655384, -0.0015841098) (0.0020655861, -0.0015839194) (0.0020656522, -0.0015837346) (0.0020657362, -0.0015835572) (0.0020658371, -0.0015833889) (0.002065954, -0.0015832312) (0.0020660858, -0.0015830858) (0.0020662312, -0.001582954) (0.0020663889, -0.0015828371) (0.0020665572, -0.0015827362) (0.0020667346, -0.0015826522) (0.0020669194, -0.0015825861) (0.0020671098, -0.0015825384) (0.002067304, -0.0015825096) (0.0020675, -0.0015825) (0.0020885, -0.0015825) (0.002088696, -0.0015825096) (0.0020888902, -0.0015825384) (0.0020890806, -0.0015825861) (0.0020892654, -0.0015826522) (0.0020894428, -0.0015827362) (0.0020896111, -0.0015828371) (0.0020897688, -0.001582954) (0.0020899142, -0.0015830858) (0.002090046, -0.0015832312) (0.0020901629, -0.0015833889) (0.0020902638, -0.0015835572) (0.0020903478, -0.0015837346) (0.0020904139, -0.0015839194) (0.0020904616, -0.0015841098) (0.0020904904, -0.001584304) (0.0020905, -0.0015845) (0.0020905, -0.0016455) (0.0020904904, -0.001645696) (0.0020904616, -0.0016458902) (0.0020904139, -0.0016460806) (0.0020903478, -0.0016462654) (0.0020902638, -0.0016464428) (0.0020901629, -0.0016466111) (0.002090046, -0.0016467688) (0.0020899142, -0.0016469142) (0.0020897688, -0.001647046) (0.0020896111, -0.0016471629) (0.0020894428, -0.0016472638) (0.0020892654, -0.0016473478) (0.0020890806, -0.0016474139) (0.0020888902, -0.0016474616) (0.002088696, -0.0016474904) (0.0020885, -0.0016475) (0.0020675, -0.0016475), closed, covered)
  head_b_cj_ch3 = polyline(z=0, xy: (0.0021115, -0.0016475) (0.002111304, -0.0016474904) (0.0021111098, -0.0016474616) (0.0021109194, -0.0016474139) (0.0021107346, -0.0016473478) (0.0021105572, -0.0016472638) (0.0021103889, -0.0016471629) (0.0021102312, -0.001647046) (0.0021100858, -0.0016469142) (0.002109954, -0.0016467688) (0.0021098371, -0.0016466111) (0.0021097362, -0.0016464428) (0.0021096522, -0.0016462654) (0.0021095861, -0.0016460806) (0.0021095384, -0.0016458902) (0.0021095096, -0.001645696) (0.0021095, -0.0016455) (0.0021095, -0.0015845) (0.0021095096, -0.001584304) (0.0021095384, -0.0015841098) (0.0021095861, -0.0015839194) (0.0021096522, -0.0015837346) (0.0021097362, -0.0015835572) (0.0021098371, -0.0015833889) (0.002109954, -0.0015832312) (0.0021100858, -0.0015830858) (0.0021102312, -0.001582954) (0.0021103889, -0.0015828371) (0.0021105572, -0.0015827362) (0.0021107346, -0.0015826522) (0.0021109194, -0.0015825861) (0.0021111098, -0.0015825384) (0.002111304, -0.0015825096) (0.0021115, -0.0015825) (0.0021325, -0.0015825) (0.002132696, -0.0015825096) (0.0021328902, -0.0015825384) (0.0021330806, -0.0015825861) (0.0021332654, -0.0015826522) (0.0021334428, -0.0015827362) (0.0021336111, -0.0015828371) (0.0021337688, -0.001582954) (0.0021339142, -0.0015830858) (0.002134046, -0.0015832312) (0.0021341629, -0.0015833889) (0.0021342638, -0.0015835572) (0.0021343478, -0.0015837346) (0.0021344139, -0.0015839194) (0.0021344616, -0.0015841098) (0.0021344904, -0.001584304) (0.0021345, -0.0015845) (0.0021345, -0.0016455) (0.0021344904, -0.001645696) (0.0021344616, -0.0016458902) (0.0021344139, -0.0016460806) (0.0021343478, -0.0016462654) (0.0021342638, -0.0016464428) (0.0021341629, -0.0016466111) (0.002134046, -0.0016467688) (0.0021339142, -0.0016469142) (0.0021337688, -0.001647046) (0.0021336111, -0.0016471629) (0.0021334428, -0.0016472638) (0.0021332654, -0.0016473478) (0.0021330806, -0.0016474139) (0.0021328902, -0.0016474616) (0.002132696, -0.0016474904) (0.0021325, -0.0016475) (0.0021115, -0.0016475), closed, covered)
  pocket_cj_ch3 = polyline(z=0, xy: (0.0020515, -0.0016635) (0.002051304, -0.0016634904) (0.0020511098, -0.0016634616) (0.0020509194, -0.0016634139) (0.0020507346, -0.0016633478) (0.0020505572, -0.0016632638) (0.0020503889, -0.0016631629) (0.0020502312, -0.001663046) (0.0020500858, -0.0016629142) (0.002049954, -0.0016627688) (0.0020498371, -0.0016626111) (0.0020497362, -0.0016624428) (0.0020496522, -0.0016622654) (0.0020495861, -0.0016620806) (0.0020495384, -0.0016618902) (0.0020495096, -0.001661696) (0.0020495, -0.0016615) (0.0020495, -0.0015685) (0.0020495096, -0.001568304) (0.0020495384, -0.0015681098) (0.0020495861, -0.0015679194) (0.0020496522, -0.0015677346) (0.0020497362, -0.0015675572) (0.0020498371, -0.0015673889) (0.002049954, -0.0015672312) (0.0020500858, -0.0015670858) (0.0020502312, -0.001566954) (0.0020503889, -0.0015668371) (0.0020505572, -0.0015667362) (0.0020507346, -0.0015666522) (0.0020509194, -0.0015665861) (0.0020511098, -0.0015665384) (0.002051304, -0.0015665096) (0.0020515, -0.0015665) (0.0021485, -0.0015665) (0.002148696, -0.0015665096) (0.0021488902, -0.0015665384) (0.0021490806, -0.0015665861) (0.0021492654, -0.0015666522) (0.0021494428, -0.0015667362) (0.0021496111, -0.0015668371) (0.0021497688, -0.001566954) (0.0021499142, -0.0015670858) (0.002150046, -0.0015672312) (0.0021501629, -0.0015673889) (0.0021502638, -0.0015675572) (0.0021503478, -0.0015677346) (0.0021504139, -0.0015679194) (0.0021504616, -0.0015681098) (0.0021504904, -0.001568304) (0.0021505, -0.0015685) (0.0021505, -0.0016615) (0.0021504904, -0.001661696) (0.0021504616, -0.0016618902) (0.0021504139, -0.0016620806) (0.0021503478, -0.0016622654) (0.0021502638, -0.0016624428) (0.0021501629, -0.0016626111) (0.002150046, -0.0016627688) (0.0021499142, -0.0016629142) (0.0021497688, -0.001663046) (0.0021496111, -0.0016631629) (0.0021494428, -0.0016632638) (0.0021492654, -0.0016633478) (0.0021490806, -0.0016634139) (0.0021488902, -0.0016634616) (0.002148696, -0.0016634904) (0.0021485, -0.0016635) (0.0020515, -0.0016635), closed, covered)
  tap_trace_n0_ch5 = polyline(z=0, xy: (0.00345, -5e-06) (0.00315, -5e-06) (0.00315, 5e-06) (0.003295, 5e-06) (0.003295, 0.0001) (0.003305, 0.0001) (0.003305, 5e-06) (0.00345, 5e-06) (0.00345, -5e-06), closed, covered)
  tap_cut_n0_ch5 = polyline(z=0, xy: (0.00345, -1.1e-05) (0.00315, -1.1e-05) (0.00315, 1.1e-05) (0.003289, 1.1e-05) (0.003289, 0.0001) (0.003311, 0.0001) (0.003311, 1.1e-05) (0.00345, 1.1e-05) (0.00345, -1.1e-05), closed, covered)
  plate_cp_ch5 = polyline(z=0, xy: (0.0032175, 0.000295) (0.0032175385, 0.00029578414) (0.0032176537, 0.00029656072) (0.0032178445, 0.00029732228) (0.003218109, 0.00029806147) (0.0032184446, 0.00029877117) (0.0032188482, 0.00029944456) (0.0032193159, 0.00030007515) (0.0032198431, 0.00030065685) (0.0032204249, 0.00030118408) (0.0032210554, 0.00030165176) (0.0032217288, 0.00030205537) (0.0032224385, 0.00030239104) (0.0032231777, 0.00030265552) (0.0032239393, 0.00030284628) (0.0032247159, 0.00030296148) (0.0032255, 0.000303) (0.0033745, 0.000303) (0.0033752841, 0.00030296148) (0.0033760607, 0.00030284628) (0.0033768223, 0.00030265552) (0.0033775615, 0.00030239104) (0.0033782712, 0.00030205537) (0.0033789446, 0.00030165176) (0.0033795751, 0.00030118408) (0.0033801569, 0.00030065685) (0.0033806841, 0.00030007515) (0.0033811518, 0.00029944456) (0.0033815554, 0.00029877117) (0.003381891, 0.00029806147) (0.0033821555, 0.00029732228) (0.0033823463, 0.00029656072) (0.0033824615, 0.00029578414) (0.0033825, 0.000295) (0.0033825, 0.00027) (0.0033824615, 0.00026921586) (0.0033823463, 0.00026843928) (0.0033821555, 0.00026767772) (0.003381891, 0.00026693853) (0.0033815554, 0.00026622883) (0.0033811518, 0.00026555544) (0.0033806841, 0.00026492485) (0.0033801569, 0.00026434315) (0.0033795751, 0.00026381592) (0.0033789446, 0.00026334824) (0.0033782712, 0.00026294463) (0.0033775615, 0.00026260896) (0.0033768223, 0.00026234448) (0.0033760607, 0.00026215372) (0.0033752841, 0.00026203852) (0.0033745, 0.000262) (0.0032255, 0.000262) (0.0032247159, 0.00026203852) (0.0032239393, 0.00026215372) (0.0032231777, 0.00026234448) (0.0032224385, 0.00026260896) (0.0032217288, 0.00026294463) (0.0032210554, 0.00026334824) (0.0032204249, 0.00026381592) (0.0032198431, 0.00026434315) (0.0032193159, 0.00026492485) (0.0032188482, 0.00026555544) (0.0032184446, 0.00026622883) (0.003218109, 0.00026693853) (0.0032178445, 0.00026767772) (0.0032176537, 0.00026843928) (0.0032175385, 0.00026921586) (0.0032175, 0.00027) (0.0032175, 0.000295), closed, covered)
  frame_cp_ch5 = polyline(z=0, xy: (0.0032175, 0.000311) (0.0032167159, 0.00031096148) (0.0032159393, 0.00031084628) (0.0032151777, 0.00031065552) (0.0032144385, 0.00031039104) (0.0032137288, 0.00031005537) (0.0032130554, 0.00030965176) (0.0032124249, 0.00030918408) (0.0032118431, 0.00030865685) (0.0032113159, 0.00030807515) (0.0032108482, 0.00030744456) (0.0032104446, 0.00030677117) (0.003210109, 0.00030606147) (0.0032098445, 0.00030532228) (0.0032096537, 0.00030456072) (0.0032095385, 0.00030378414) (0.0032095, 0.000303) (0.0032095, 0.000262) (0.0032095385, 0.00026121586) (0.0032096537, 0.00026043928) (0.0032098445, 0.00025967772) (0.003210109, 0.00025893853) (0.0032104446, 0.00025822883) (0.0032108482, 0.00025755544) (0.0032113159, 0.00025692485) (0.0032118431, 0.00025634315) (0.0032124249, 0.00025581592) (0.0032130554, 0.00025534824) (0.0032137288, 0.00025494463) (0.0032144385, 0.00025460896) (0.0032151777, 0.00025434448) (0.0032159393, 0.00025415372) (0.0032167159, 0.00025403852) (0.0032175, 0.000254) (0.0032809018, 0.000254) (0.0032810981, 0.00025399518) (0.003281588, 0.00025397111) (0.0032819784, 0.00025393266) (0.0032823665, 0.0002538751) (0.0032827512, 0.00025379856) (0.0032831318, 0.00025370324) (0.0032835072, 0.00025358936) (0.0032838766, 0.0002534572) (0.003284239, 0.00025330707) (0.0032845936, 0.00025313934) (0.0032849396, 0.00025295441) (0.0032852761, 0.00025275272) (0.0032856023, 0.00025253477) (0.0032859174, 0.00025230107) (0.0032862207, 0.0002520522) (0.0032865113, 0.00025178874) (0.0032867887, 0.00025151134) (0.0032870522, 0.00025122066) (0.0032873011, 0.0002509174) (0.0032875348, 0.0002506023) (0.0032877527, 0.00025027611) (0.0032879544, 0.00024993962) (0.0032881393, 0.00024959364) (0.0032883071, 0.000249239) (0.0032884572, 0.00024887656) (0.0032885894, 0.00024850719) (0.0032887032, 0.00024813177) (0.0032887986, 0.00024775123) (0.0032888751, 0.00024736646) (0.0032889327, 0.0002469784) (0.0032889711, 0.00024658799) (0.0032889952, 0.00024609806) (0.003289, 0.00024590182) (0.003289, 0.00019809818) (0.0032889952, 0.00019790194) (0.0032889711, 0.00019741201) (0.0032889327, 0.0001970216) (0.0032888751, 0.00019663354) (0.0032887986, 0.00019624877) (0.0032887032, 0.00019586823) (0.0032885894, 0.00019549281) (0.0032884572, 0.00019512344) (0.0032883071, 0.000194761) (0.0032881393, 0.00019440636) (0.0032879544, 0.00019406038) (0.0032877527, 0.00019372389) (0.0032875348, 0.0001933977) (0.0032873011, 0.00019308259) (0.0032870522, 0.00019277934) (0.0032867887, 0.00019248866) (0.0032865113, 0.00019221126) (0.0032862207, 0.0001919478) (0.0032859174, 0.00019169893) (0.0032856023, 0.00019146523) (0.0032852761, 0.00019124728) (0.0032849396, 0.00019104559) (0.0032845936, 0.00019086066) (0.003284239, 0.00019069293) (0.0032838766, 0.0001905428) (0.0032835072, 0.00019041064) (0.0032831318, 0.00019029676) (0.0032827512, 0.00019020144) (0.0032823665, 0.0001901249) (0.0032819784, 0.00019006734) (0.003281588, 0.00019002889) (0.0032810981, 0.00019000482) (0.0032809018, 0.00019) (0.0031605982, 0.00019) (0.0031604019, 0.00019000482) (0.003159912, 0.00019002889) (0.0031595216, 0.00019006734) (0.0031591335, 0.0001901249) (0.0031587488, 0.00019020144) (0.0031583682, 0.00019029676) (0.0031579928, 0.00019041064) (0.0031576234, 0.0001905428) (0.003157261, 0.00019069293) (0.0031569064, 0.00019086066) (0.0031565604, 0.00019104559) (0.0031562239, 0.00019124728) (0.0031558977, 0.00019146523) (0.0031555826, 0.00019169893) (0.0031552793, 0.0001919478) (0.0031549887, 0.00019221126) (0.0031547113, 0.00019248866) (0.0031544478, 0.00019277934) (0.0031541989, 0.00019308259) (0.0031539652, 0.0001933977) (0.0031537473, 0.00019372389) (0.0031535456, 0.00019406038) (0.0031533607, 0.00019440636) (0.0031531929, 0.000194761) (0.0031530428, 0.00019512344) (0.0031529106, 0.00019549281) (0.0031527968, 0.00019586823) (0.0031527014, 0.00019624877) (0.0031526249, 0.00019663354) (0.0031525673, 0.0001970216) (0.0031525289, 0.00019741201) (0.0031525048, 0.00019790194) (0.0031525, 0.00019809818) (0.0031525, 0.00035490182) (0.0031525048, 0.00035509806) (0.0031525289, 0.00035558799) (0.0031525673, 0.0003559784) (0.0031526249, 0.00035636646) (0.0031527014, 0.00035675123) (0.0031527968, 0.00035713177) (0.0031529106, 0.00035750719) (0.0031530428, 0.00035787656) (0.0031531929, 0.000358239) (0.0031533607, 0.00035859364) (0.0031535456, 0.00035893962) (0.0031537473, 0.00035927611) (0.0031539652, 0.0003596023) (0.0031541989, 0.00035991741) (0.0031544478, 0.00036022066) (0.0031547113, 0.00036051134) (0.0031549887, 0.00036078874) (0.0031552793, 0.0003610522) (0.0031555826, 0.00036130107) (0.0031558977, 0.00036153477) (0.0031562239, 0.00036175272) (0.0031565604, 0.00036195441) (0.0031569064, 0.00036213934) (0.003157261, 0.00036230707) (0.0031576234, 0.0003624572) (0.0031579928, 0.00036258936) (0.0031583682, 0.00036270324) (0.0031587488, 0.00036279856) (0.0031591335, 0.0003628751) (0.0031595216, 0.00036293266) (0.003159912, 0.00036297111) (0.0031604019, 0.00036299518) (0.0031605982, 0.000363) (0.0034394018, 0.000363) (0.0034395981, 0.00036299518) (0.003440088, 0.00036297111) (0.0034404784, 0.00036293266) (0.0034408665, 0.0003628751) (0.0034412512, 0.00036279856) (0.0034416318, 0.00036270324) (0.0034420072, 0.00036258936) (0.0034423766, 0.0003624572) (0.003442739, 0.00036230707) (0.0034430936, 0.00036213934) (0.0034434396, 0.00036195441) (0.0034437761, 0.00036175272) (0.0034441023, 0.00036153477) (0.0034444174, 0.00036130107) (0.0034447207, 0.0003610522) (0.0034450113, 0.00036078874) (0.0034452887, 0.00036051134) (0.0034455522, 0.00036022066) (0.0034458011, 0.00035991741) (0.0034460348, 0.0003596023) (0.0034462527, 0.00035927611) (0.0034464544, 0.00035893962) (0.0034466393, 0.00035859364) (0.0034468071, 0.000358239) (0.0034469572, 0.00035787656) (0.0034470894, 0.00035750719) (0.0034472032, 0.00035713177) (0.0034472986, 0.00035675123) (0.0034473751, 0.00035636646) (0.0034474327, 0.0003559784) (0.0034474711, 0.00035558799) (0.0034474952, 0.00035509806) (0.0034475, 0.00035490182) (0.0034475, 0.00019809818) (0.0034474952, 0.00019790194) (0.0034474711, 0.00019741201) (0.0034474327, 0.0001970216) (0.0034473751, 0.00019663354) (0.0034472986, 0.00019624877) (0.0034472032, 0.00019586823) (0.0034470894, 0.00019549281) (0.0034469572, 0.00019512344) (0.0034468071, 0.000194761) (0.0034466393, 0.00019440636) (0.0034464544, 0.00019406038) (0.0034462527, 0.00019372389) (0.0034460348, 0.0001933977) (0.0034458011, 0.00019308259) (0.0034455522, 0.00019277934) (0.0034452887, 0.00019248866) (0.0034450113, 0.00019221126) (0.0034447207, 0.0001919478) (0.0034444174, 0.00019169893) (0.0034441023, 0.00019146523) (0.0034437761, 0.00019124728) (0.0034434396, 0.00019104559) (0.0034430936, 0.00019086066) (0.003442739, 0.00019069293) (0.0034423766, 0.0001905428) (0.0034420072, 0.00019041064) (0.0034416318, 0.00019029676) (0.0034412512, 0.00019020144) (0.0034408665, 0.0001901249) (0.0034404784, 0.00019006734) (0.003440088, 0.00019002889) (0.0034395981, 0.00019000482) (0.0034394018, 0.00019) (0.0033190982, 0.00019) (0.0033189019, 0.00019000482) (0.003318412, 0.00019002889) (0.0033180216, 0.00019006734) (0.0033176335, 0.0001901249) (0.0033172488, 0.00019020144) (0.0033168682, 0.00019029676) (0.0033164928, 0.00019041064) (0.0033161234, 0.0001905428) (0.003315761, 0.00019069293) (0.0033154064, 0.00019086066) (0.0033150604, 0.00019104559) (0.0033147239, 0.00019124728) (0.0033143977, 0.00019146523) (0.0033140826, 0.00019169893) (0.0033137793, 0.0001919478) (0.0033134887, 0.00019221126) (0.0033132113, 0.00019248866) (0.0033129478, 0.00019277934) (0.0033126989, 0.00019308259) (0.0033124652, 0.0001933977) (0.0033122473, 0.00019372389) (0.0033120456, 0.00019406038) (0.0033118607, 0.00019440636) (0.0033116929, 0.000194761) (0.0033115428, 0.00019512344) (0.0033114106, 0.00019549281) (0.0033112968, 0.00019586823) (0.0033112014, 0.00019624877) (0.0033111249, 0.00019663354) (0.0033110673, 0.0001970216) (0.0033110289, 0.00019741201) (0.0033110048, 0.00019790194) (0.003311, 0.00019809818) (0.003311, 0.00024590182) (0.0033110048, 0.00024609806) (0.0033110289, 0.00024658799) (0.0033110673, 0.0002469784) (0.0033111249, 0.00024736646) (0.0033112014, 0.00024775123) (0.0033112968, 0.00024813177) (0.0033114106, 0.00024850719) (0.0033115428, 0.00024887656) (0.0033116929, 0.000249239) (0.0033118607, 0.00024959364) (0.0033120456, 0.00024993962) (0.0033122473, 0.00025027611) (0.0033124652, 0.0002506023) (0.0033126989, 0.0002509174) (0.0033129478, 0.00025122066) (0.0033132113, 0.00025151134) (0.0033134887, 0.00025178874) (0.0033137793, 0.0002520522) (0.0033140826, 0.00025230107) (0.0033143977, 0.00025253477) (0.0033147239, 0.00025275272) (0.0033150604, 0.00025295441) (0.0033154064, 0.00025313934) (0.003315761, 0.00025330707) (0.0033161234, 0.0002534572) (0.0033164928, 0.00025358936) (0.0033168682, 0.00025370324)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, closed, covered)
  pocket_cp_ch5 = polyline(z=0, xy: (0.0031525, 0.000375) (0.0034475, 0.000375) (0.0034486762, 0.00037494222) (0.0034498411, 0.00037476942) (0.0034509834, 0.00037448328) (0.0034520922, 0.00037408655) (0.0034531568, 0.00037358305) (0.0034541668, 0.00037297763) (0.0034551127, 0.00037227612) (0.0034559853, 0.00037148528) (0.0034567761, 0.00037061272) (0.0034574776, 0.00036966684) (0.0034580831, 0.00036865676) (0.0034585866, 0.0003675922) (0.0034589833, 0.00036648342) (0.0034592694, 0.00036534108) (0.0034594422, 0.00036417621) (0.0034595, 0.000363) (0.0034595, 0.00019) (0.0034594422, 0.00018882379) (0.0034592694, 0.00018765892) (0.0034589833, 0.00018651658) (0.0034585866, 0.0001854078) (0.0034580831, 0.00018434324) (0.0034574776, 0.00018333316) (0.0034567761, 0.00018238728) (0.0034559853, 0.00018151472) (0.0034551127, 0.00018072388) (0.0034541668, 0.00018002237) (0.0034531568, 0.00017941694) (0.0034520922, 0.00017891345) (0.0034509834, 0.00017851672) (0.0034498411, 0.00017823058) (0.0034486762, 0.00017805778) (0.0034475, 0.000178) (0.0031525, 0.000178) (0.0031513238, 0.00017805778) (0.0031501589, 0.00017823058) (0.0031490166, 0.00017851672) (0.0031479078, 0.00017891345) (0.0031468432, 0.00017941694) (0.0031458332, 0.00018002237) (0.0031448873, 0.00018072388) (0.0031440147, 0.00018151472) (0.0031432239, 0.00018238728) (0.0031425224, 0.00018333316) (0.0031419169, 0.00018434324) (0.0031414134, 0.0001854078) (0.0031410167, 0.00018651658) (0.0031407306, 0.00018765892) (0.0031405578, 0.00018882379) (0.0031405, 0.00019) (0.0031405, 0.000363) (0.0031405578, 0.00036417621) (0.0031407306, 0.00036534108) (0.0031410167, 0.00036648342) (0.0031414134, 0.0003675922) (0.0031419169, 0.00036865676) (0.0031425224, 0.00036966684) (0.0031432239, 0.00037061272) (0.0031440147, 0.00037148528) (0.0031448873, 0.00037227612) (0.0031458332, 0.00037297763) (0.0031468432, 0.00037358305) (0.0031479078, 0.00037408655) (0.0031490166, 0.00037448328) (0.0031501589, 0.00037476942) (0.0031513238, 0.00037494222) (0.0031525, 0.000375), closed, covered)
  tap_trace_jf_ch5 = polyline(z=0, xy: (0.003295, 0.001465) (0.003295, 0.001765) (0.003305, 0.001765) (0.003305, 0.00162) (0.0033355, 0.00162) (0.0033355, 0.00161) (0.003305, 0.00161) (0.003305, 0.001465) (0.003295, 0.001465), closed, covered)
  tap_cut_jf_ch5 = polyline(z=0, xy: (0.003289, 0.001465) (0.003289, 0.001765) (0.003311, 0.001765) (0.003311, 0.001626) (0.0033355, 0.001626) (0.0033355, 0.001604) (0.003311, 0.001604) (0.003311, 0.001465) (0.003289, 0.001465), closed, covered)
  tap_trace_jr_ch5 = polyline(z=0, xy: (0.0034645, 0.00162) (0.003495, 0.00162) (0.003495, 0.001765) (0.003505, 0.001765) (0.003505, 0.001465) (0.003495, 0.001465) (0.003495, 0.00161) (0.0034645, 0.00161) (0.0034645, 0.00162), closed, covered)
  tap_cut_jr_ch5 = polyline(z=0, xy: (0.0034645, 0.001626) (0.003489, 0.001626) (0.003489, 0.001765) (0.003511, 0.001765) (0.003511, 0.001465) (0.003489, 0.001465) (0.003489, 0.001604) (0.0034645, 0.001604) (0.0034645, 0.001626), closed, covered)
  head_a_cj_ch5 = polyline(z=0, xy: (0.0033675, 0.0015825) (0.003367304, 0.0015825096) (0.0033671098, 0.0015825384) (0.0033669194, 0.0015825861) (0.0033667346, 0.0015826522) (0.0033665572, 0.0015827362) (0.0033663889, 0.0015828371) (0.0033662312, 0.001582954) (0.0033660858, 0.0015830858) (0.003365954, 0.0015832312) (0.0033658371, 0.0015833889) (0.0033657362, 0.0015835572) (0.0033656522, 0.0015837346) (0.0033655861, 0.0015839194) (0.0033655384, 0.0015841098) (0.0033655096, 0.001584304) (0.0033655, 0.0015845) (0.0033655, 0.0016455) (0.0033655096, 0.001645696) (0.0033655384, 0.0016458902) (0.0033655861, 0.0016460806) (0.0033656522, 0.0016462654) (0.0033657362, 0.0016464428) (0.0033658371, 0.0016466111) (0.003365954, 0.0016467688) (0.0033660858, 0.0016469142) (0.0033662312, 0.001647046) (0.0033663889, 0.0016471629) (0.0033665572, 0.0016472638) (0.0033667346, 0.0016473478) (0.0033669194, 0.0016474139) (0.0033671098, 0.0016474616) (0.003367304, 0.0016474904) (0.0033675, 0.0016475) (0.0033885, 0.0016475) (0.003388696, 0.0016474904) (0.0033888902, 0.0016474616) (0.0033890806, 0.0016474139) (0.0033892654, 0.0016473478) (0.0033894428, 0.0016472638) (0.0033896111, 0.0016471629) (0.0033897688, 0.001647046) (0.0033899142, 0.0016469142) (0.003390046, 0.0016467688) (0.0033901629, 0.0016466111) (0.0033902638, 0.0016464428) (0.0033903478, 0.0016462654) (0.0033904139, 0.0016460806) (0.0033904616, 0.0016458902) (0.0033904904, 0.001645696) (0.0033905, 0.0016455) (0.0033905, 0.0015845) (0.0033904904, 0.001584304) (0.0033904616, 0.0015841098) (0.0033904139, 0.0015839194) (0.0033903478, 0.0015837346) (0.0033902638, 0.0015835572) (0.0033901629, 0.0015833889) (0.003390046, 0.0015832312) (0.0033899142, 0.0015830858) (0.0033897688, 0.001582954) (0.0033896111, 0.0015828371) (0.0033894428, 0.0015827362) (0.0033892654, 0.0015826522) (0.0033890806, 0.0015825861) (0.0033888902, 0.0015825384) (0.003388696, 0.0015825096) (0.0033885, 0.0015825) (0.0033675, 0.0015825), closed, covered)
  head_b_cj_ch5 = polyline(z=0, xy: (0.0034115, 0.0015825) (0.003411304, 0.0015825096) (0.0034111098, 0.0015825384) (0.0034109194, 0.0015825861) (0.0034107346, 0.0015826522) (0.0034105572, 0.0015827362) (0.0034103889, 0.0015828371) (0.0034102312, 0.001582954) (0.0034100858, 0.0015830858) (0.003409954, 0.0015832312) (0.0034098371, 0.0015833889) (0.0034097362, 0.0015835572) (0.0034096522, 0.0015837346) (0.0034095861, 0.0015839194) (0.0034095384, 0.0015841098) (0.0034095096, 0.001584304) (0.0034095, 0.0015845) (0.0034095, 0.0016455) (0.0034095096, 0.001645696) (0.0034095384, 0.0016458902) (0.0034095861, 0.0016460806) (0.0034096522, 0.0016462654) (0.0034097362, 0.0016464428) (0.0034098371, 0.0016466111) (0.003409954, 0.0016467688) (0.0034100858, 0.0016469142) (0.0034102312, 0.001647046) (0.0034103889, 0.0016471629) (0.0034105572, 0.0016472638) (0.0034107346, 0.0016473478) (0.0034109194, 0.0016474139) (0.0034111098, 0.0016474616) (0.003411304, 0.0016474904) (0.0034115, 0.0016475) (0.0034325, 0.0016475) (0.003432696, 0.0016474904) (0.0034328902, 0.0016474616) (0.0034330806, 0.0016474139) (0.0034332654, 0.0016473478) (0.0034334428, 0.0016472638) (0.0034336111, 0.0016471629) (0.0034337688, 0.001647046) (0.0034339142, 0.0016469142) (0.003434046, 0.0016467688) (0.0034341629, 0.0016466111) (0.0034342638, 0.0016464428) (0.0034343478, 0.0016462654) (0.0034344139, 0.0016460806) (0.0034344616, 0.0016458902) (0.0034344904, 0.001645696) (0.0034345, 0.0016455) (0.0034345, 0.0015845) (0.0034344904, 0.001584304) (0.0034344616, 0.0015841098) (0.0034344139, 0.0015839194) (0.0034343478, 0.0015837346) (0.0034342638, 0.0015835572) (0.0034341629, 0.0015833889) (0.003434046, 0.0015832312) (0.0034339142, 0.0015830858) (0.0034337688, 0.001582954) (0.0034336111, 0.0015828371) (0.0034334428, 0.0015827362) (0.0034332654, 0.0015826522) (0.0034330806, 0.0015825861) (0.0034328902, 0.0015825384) (0.003432696, 0.0015825096) (0.0034325, 0.0015825) (0.0034115, 0.0015825), closed, covered)
  pocket_cj_ch5 = polyline(z=0, xy: (0.0033515, 0.0015665) (0.003351304, 0.0015665096) (0.0033511098, 0.0015665384) (0.0033509194, 0.0015665861) (0.0033507346, 0.0015666522) (0.0033505572, 0.0015667362) (0.0033503889, 0.0015668371) (0.0033502312, 0.001566954) (0.0033500858, 0.0015670858) (0.003349954, 0.0015672312) (0.0033498371, 0.0015673889) (0.0033497362, 0.0015675572) (0.0033496522, 0.0015677346) (0.0033495861, 0.0015679194) (0.0033495384, 0.0015681098) (0.0033495096, 0.001568304) (0.0033495, 0.0015685) (0.0033495, 0.0016615) (0.0033495096, 0.001661696) (0.0033495384, 0.0016618902) (0.0033495861, 0.0016620806) (0.0033496522, 0.0016622654) (0.0033497362, 0.0016624428) (0.0033498371, 0.0016626111) (0.003349954, 0.0016627688) (0.0033500858, 0.0016629142) (0.0033502312, 0.001663046) (0.0033503889, 0.0016631629) (0.0033505572, 0.0016632638) (0.0033507346, 0.0016633478) (0.0033509194, 0.0016634139) (0.0033511098, 0.0016634616) (0.003351304, 0.0016634904) (0.0033515, 0.0016635) (0.0034485, 0.0016635) (0.003448696, 0.0016634904) (0.0034488902, 0.0016634616) (0.0034490806, 0.0016634139) (0.0034492654, 0.0016633478) (0.0034494428, 0.0016632638) (0.0034496111, 0.0016631629) (0.0034497688, 0.001663046) (0.0034499142, 0.0016629142) (0.003450046, 0.0016627688) (0.0034501629, 0.0016626111) (0.0034502638, 0.0016624428) (0.0034503478, 0.0016622654) (0.0034504139, 0.0016620806) (0.0034504616, 0.0016618902) (0.0034504904, 0.001661696) (0.0034505, 0.0016615) (0.0034505, 0.0015685) (0.0034504904, 0.001568304) (0.0034504616, 0.0015681098) (0.0034504139, 0.0015679194) (0.0034503478, 0.0015677346) (0.0034502638, 0.0015675572) (0.0034501629, 0.0015673889) (0.003450046, 0.0015672312) (0.0034499142, 0.0015670858) (0.0034497688, 0.001566954) (0.0034496111, 0.0015668371) (0.0034494428, 0.0015667362) (0.0034492654, 0.0015666522) (0.0034490806, 0.0015665861) (0.0034488902, 0.0015665384) (0.003448696, 0.0015665096) (0.0034485, 0.0015665) (0.0033515, 0.0015665), closed, covered)
  endcap_res_a_ch2_start = rectangle(corner=(-0.003011, -0.002921, 0), x_size=2.2e-05, y_size=6e-06)
  endcap_res_a_ch4_start = rectangle(corner=(-0.001711, 0.002915, 0), x_size=2.2e-05, y_size=6e-06)
  endcap_res_a_ch6_start = rectangle(corner=(-0.000411, -0.002921, 0), x_size=2.2e-05, y_size=6e-06)
  endcap_res_a_ch1_start = rectangle(corner=(0.000889, 0.002915, 0), x_size=2.2e-05, y_size=6e-06)
  endcap_res_a_ch3_start = rectangle(corner=(0.002189, -0.002921, 0), x_size=2.2e-05, y_size=6e-06)
  endcap_res_a_ch5_start = rectangle(corner=(0.003489, 0.002915, 0), x_size=2.2e-05, y_size=6e-06)
  endcap_feed_in_start = rectangle(corner=(-0.004476, -1.1e-05, 0), x_size=6e-06, y_size=2.2e-05)
  endcap_fl_6_end = rectangle(corner=(0.00447, -1.1e-05, 0), x_size=6e-06, y_size=2.2e-05)
  ground_main_plane = rectangle(corner=(-0.00467, -0.003115, 0), x_size=0.00934, y_size=0.00623)
  main [silicon] = box(corner=(-0.00467, -0.003115, -0.000525), size=(0.00934, 0.00623, 0.000525))
  sample_holder [vacuum] = box(corner=(-0.00467, -0.003115, -0.00165), size=(0.00934, 0.00623, 0.00254))
  ground_main_plane.subtract(cut_stub_r_ch3, lead_b_sub_cp_ch4, cut_feed_jf_ch4, lead_b_sub_cj_ch5, cut_fl_5, cut_fl_4, cut_res_ch3, cut_stub_p_ch2, lead_b_sub_cin, lead_b_sub_cp_ch3, tap_cut_jr_ch6, cut_feed_jf_ch6, cut_filt_ch5, cut_fl_2, endcap_res_a_ch6_start, tap_cut_jf_ch2, cut_filt_ch1, cut_stub_r_ch1, lead_a_sub_cp_ch3, cut_feed_jf_ch1, pocket_cj_ch5, lead_b_sub_cp_ch2, pocket_cj_ch2, tap_cut_n0_ch6, cut_fl_0, pocket_cp_ch6, cut_fl_3, tap_cut_jr_ch4, tap_cut_n0_ch3, lead_a_sub_cj_ch4, cut_filt_ch3, cut_res_a_ch1, cut_stub_f_ch3, tap_cut_jf_ch6, cut_feed_jf_ch3, lead_a_sub_cp_ch1, tap_cut_n0_ch2, cut_filt_ch4, endcap_res_a_ch3_start, cut_stub_p_ch5, pocket_cj_ch3, cut_res_a_ch4, cut_stub_r_ch6, pocket_cp_ch5, cut_fl_6, endcap_res_a_ch5_start, cut_stub_p_ch6, pocket_cj_ch4, cut_stub_r_ch4, cut_stub_f_ch6, cut_feed_jf_ch5, cut_res_a_ch6, lead_a_sub_cj_ch2, tap_cut_n0_ch5, lead_a_sub_cp_ch6, endcap_res_a_ch2_start, lead_a_sub_cj_ch6, tap_cut_jf_ch4, cut_stub_r_ch5, endcap_res_a_ch4_start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)
  Port_feed_in_start = rectangle(corner=(-0.004476, -5e-06, 0), x_size=6e-06, y_size=1e-05)
  voltage_line_Port_feed_in_start = polyline((-0.00447, 0, 0) (-0.004476, 0, 0))
  Port_fl_6_end = rectangle(corner=(0.00447, -5e-06, 0), x_size=6e-06, y_size=1e-05)
  voltage_line_Port_fl_6_end = polyline((0.00447, 0, 0) (0.004476, 0, 0))
boundaries and excitations:
  PerfE: Perfect E Objects=[lead_a_cin, lead_b_cin, lead_a_cp_ch2, lead_b_cp_ch2, trace_stub_p_ch2, trace_feed_jf_ch2, lead_a_cj_ch2, lead_b_cj_ch2, trace_stub_f_ch2, trace_stub_r_ch2, trace_filt_ch2, trace_res_a_ch2, trace_res_ch2, lead_a_cp_ch4, lead_b_cp_ch4, trace_stub_p_ch4, trace_feed_jf_ch4, lead_a_cj_ch4, lead_b_cj_ch4, trace_stub_f_ch4, trace_stub_r_ch4, trace_filt_ch4, trace_res_a_ch4, trace_res_ch4, lead_a_cp_ch6, lead_b_cp_ch6, trace_stub_p_ch6, trace_feed_jf_ch6, lead_a_cj_ch6, lead_b_cj_ch6, trace_stub_f_ch6, trace_stub_r_ch6, trace_filt_ch6, trace_res_a_ch6, trace_res_ch6, lead_a_cp_ch1, lead_b_cp_ch1, trace_stub_p_ch1, trace_feed_jf_ch1, lead_a_cj_ch1, lead_b_cj_ch1, trace_stub_f_ch1, trace_stub_r_ch1, trace_filt_ch1, trace_res_a_ch1, trace_res_ch1, lead_a_cp_ch3, lead_b_cp_ch3, trace_stub_p_ch3, trace_feed_jf_ch3, lead_a_cj_ch3, lead_b_cj_ch3, trace_stub_f_ch3, trace_stub_r_ch3, trace_filt_ch3, trace_res_a_ch3, trace_res_ch3, lead_a_cp_ch5, lead_b_cp_ch5, trace_stub_p_ch5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]
  LumpPort_feed_in_start: Lumped Port Objects=Port_feed_in_start Modes{Mode1{IntLine{middle of Port_feed_in_start.edge(x at corner) -> middle of Port_feed_in_start.edge(x opposite corner)} CharImp=Zpi RenormImp=50ohm}} Impedance=50ohm
  LumpPort_fl_6_end: Lumped Port Objects=Port_fl_6_end Modes{Mode1{IntLine{middle of Port_fl_6_end.edge(x at corner) -> middle of Port_fl_6_end.edge(x opposite corner)} CharImp=Zpi RenormImp=50ohm}} Impedance=50ohm
setups:
  Setup: HfssDriven Frequency=6.8GHz MaxDeltaS=0.003 MaximumPasses=14 MinimumPasses=6 MinimumConvergedPasses=2 PercentRefinement=30 BasisOrder=2 PortAccuracy=2
    sweep Sweep: 6.1GHz to 7.5GHz, 5601 points; Type=Fast
source amplitudes:
  LumpPort_feed_in_start:1: 1W 0deg
  LumpPort_fl_6_end:1: 0W 0deg
field plots:
  Mesh1: MeshPlots in main on Setup : LastAdaptive at Freq=6.8GHz Phase=0deg
  Mag_E1: E Field in main on Setup : LastAdaptive at Freq=6.8GHz Phase=0deg
reports:
  S Parameter Plot 1: dB(S(LumpPort_feed_in_start,LumpPort_feed_in_start)), dB(S(LumpPort_fl_6_end,LumpPort_feed_in_start)), dB(S(LumpPort_feed_in_start,LumpPort_fl_6_end)), dB(S(LumpPort_fl_6_end,LumpPort_fl_6_end)) vs Freq on Setup : Sweep

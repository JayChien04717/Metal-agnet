# Ansys Electronics Desktop project, version 2021.2
materials:
  silicon: permittivity=11.9
  silicon_eps11p5: permittivity=11.5
  vacuum: permittivity=1
  copper: permeability=0.999991 conductivity=58000000
  pec: conductivity=1e+30

design Q400g26_1648_q3d (Q3D Extractor, model units mm)
options: SParamCalcMethod=EqTransLine Calculate_Lossy_Dielectrics
geometry:
  lead_a_cin_path = polyline((-0.000744499, 0, 0) (-0.0007925, 0, 0))
  lead_a_cin [copper] = polyline((-0.000744499, -8e-06, 0) (-0.000744499, 8e-06, 0))
  lead_a_cin.sweep_along_path(lead_a_cin_path)
  lead_a_sub_cin_path = polyline((-0.000744499, 0, 0) (-0.0007925, 0, 0))
  lead_a_sub_cin = polyline((-0.000744499, -1.7e-05, 0) (-0.000744499, 1.7e-05, 0))
  lead_a_sub_cin.sweep_along_path(lead_a_sub_cin_path)
  lead_b_cin_path = polyline((-0.000639501, 0, 0) (-0.0005275, 0, 0))
  lead_b_cin [copper] = polyline((-0.000639501, 8e-06, 0) (-0.000639501, -8e-06, 0))
  lead_b_cin.sweep_along_path(lead_b_cin_path)
  lead_b_sub_cin_path = polyline((-0.000639501, 0, 0) (-0.0005275, 0, 0))
  lead_b_sub_cin = polyline((-0.000639501, 1.7e-05, 0) (-0.000639501, -1.7e-05, 0))
  lead_b_sub_cin.sweep_along_path(lead_b_sub_cin_path)
  lead_a_cp_path = polyline((0, 0.000198001, 0) (0, 0.00015, 0))
  lead_a_cp [copper] = polyline((8e-06, 0.000198001, 0) (-8e-06, 0.000198001, 0))
  lead_a_cp.sweep_along_path(lead_a_cp_path)
  lead_a_sub_cp_path = polyline((0, 0.000198001, 0) (0, 0.00015, 0))
  lead_a_sub_cp = polyline((1.7e-05, 0.000198001, 0) (-1.7e-05, 0.000198001, 0))
  lead_a_sub_cp.sweep_along_path(lead_a_sub_cp_path)
  lead_b_cp_path = polyline((0, 0.000302999, 0) (0, 0.000415, 0))
  lead_b_cp [copper] = polyline((-8e-06, 0.000302999, 0) (8e-06, 0.000302999, 0))
  lead_b_cp.sweep_along_path(lead_b_cp_path)
  lead_b_sub_cp_path = polyline((0, 0.000302999, 0) (0, 0.000415, 0))
  lead_b_sub_cp = polyline((-1.7e-05, 0.000302999, 0) (1.7e-05, 0.000302999, 0))
  lead_b_sub_cp.sweep_along_path(lead_b_sub_cp_path)
  trace_feed_in_path = polyline((-0.00162, 0, 0) (-0.0007925, 0, 0))
  trace_feed_in [copper] = polyline((-0.00162, 8e-06, 0) (-0.00162, -8e-06, 0))
  trace_feed_in.sweep_along_path(trace_feed_in_path)
  cut_feed_in_path = polyline((-0.00162, 0, 0) (-0.0007925, 0, 0))
  cut_feed_in = polyline((-0.00162, 1.7e-05, 0) (-0.00162, -1.7e-05, 0))
  cut_feed_in.sweep_along_path(cut_feed_in_path)
  trace_feed_mid_path = polyline((-0.0005275, 0, 0) (-0.00015, 0, 0))
  trace_feed_mid [copper] = polyline((-0.0005275, 8e-06, 0) (-0.0005275, -8e-06, 0))
  trace_feed_mid.sweep_along_path(trace_feed_mid_path)
  cut_feed_mid_path = polyline((-0.0005275, 0, 0) (-0.00015, 0, 0))
  cut_feed_mid = polyline((-0.0005275, 1.7e-05, 0) (-0.0005275, -1.7e-05, 0))
  cut_feed_mid.sweep_along_path(cut_feed_mid_path)
  trace_feed_out_path = polyline((0.00015, 0, 0) (0.00162, 0, 0))
  trace_feed_out [copper] = polyline((0.00015, 8e-06, 0) (0.00015, -8e-06, 0))
  trace_feed_out.sweep_along_path(trace_feed_out_path)
  cut_feed_out_path = polyline((0.00015, 0, 0) (0.00162, 0, 0))
  cut_feed_out = polyline((0.00015, 1.7e-05, 0) (0.00015, -1.7e-05, 0))
  cut_feed_out.sweep_along_path(cut_feed_out_path)
  trace_stub_p_path = polyline((0, 0.0001, 0) (0, 0.00015, 0))
  trace_stub_p [copper] = polyline((-8e-06, 0.0001, 0) (8e-06, 0.0001, 0))
  trace_stub_p.sweep_along_path(trace_stub_p_path)
  cut_stub_p_path = polyline((0, 0.0001, 0) (0, 0.00015, 0))
  cut_stub_p = polyline((-1.7e-05, 0.0001, 0) (1.7e-05, 0.0001, 0))
  cut_stub_p.sweep_along_path(cut_stub_p_path)
  lead_a_cj_path = polyline((0.000162001, 0.001615, 0) (0.000152, 0.001615, 0))
  lead_a_cj [copper] = polyline((0.000162001, 0.001607, 0) (0.000162001, 0.001623, 0))
  lead_a_cj.sweep_along_path(lead_a_cj_path)
  lead_a_sub_cj_path = polyline((0.000162001, 0.001615, 0) (0.000152, 0.001615, 0))
  lead_a_sub_cj = polyline((0.000162001, 0.001598, 0) (0.000162001, 0.001632, 0))
  lead_a_sub_cj.sweep_along_path(lead_a_sub_cj_path)
  lead_b_cj_path = polyline((0.000237999, 0.001615, 0) (0.000248, 0.001615, 0))
  lead_b_cj [copper] = polyline((0.000237999, 0.001623, 0) (0.000237999, 0.001607, 0))
  lead_b_cj.sweep_along_path(lead_b_cj_path)
  lead_b_sub_cj_path = polyline((0.000237999, 0.001615, 0) (0.000248, 0.001615, 0))
  lead_b_sub_cj = polyline((0.000237999, 0.001632, 0) (0.000237999, 0.001598, 0))
  lead_b_sub_cj.sweep_along_path(lead_b_sub_cj_path)
  trace_stub_f_path = polyline((0.000132, 0.001615, 0) (0.000152, 0.001615, 0))
  trace_stub_f [copper] = polyline((0.000132, 0.001623, 0) (0.000132, 0.001607, 0))
  trace_stub_f.sweep_along_path(trace_stub_f_path)
  cut_stub_f_path = polyline((0.000132, 0.001615, 0) (0.000152, 0.001615, 0))
  cut_stub_f = polyline((0.000132, 0.001632, 0) (0.000132, 0.001598, 0))
  cut_stub_f.sweep_along_path(cut_stub_f_path)
  trace_stub_r_path = polyline((0.000248, 0.001615, 0) (0.000268, 0.001615, 0))
  trace_stub_r [copper] = polyline((0.000248, 0.001623, 0) (0.000248, 0.001607, 0))
  trace_stub_r.sweep_along_path(trace_stub_r_path)
  cut_stub_r_path = polyline((0.000248, 0.001615, 0) (0.000268, 0.001615, 0))
  cut_stub_r = polyline((0.000248, 0.001632, 0) (0.000248, 0.001598, 0))
  cut_stub_r.sweep_along_path(cut_stub_r_path)
  trace_feed_jf_path = polyline((0, 0.000415, 0) (0, 0.001465, 0))
  trace_feed_jf [copper] = polyline((-8e-06, 0.000415, 0) (8e-06, 0.000415, 0))
  trace_feed_jf.sweep_along_path(trace_feed_jf_path)
  cut_feed_jf_path = polyline((0, 0.000415, 0) (0, 0.001465, 0))
  cut_feed_jf = polyline((-1.7e-05, 0.000415, 0) (1.7e-05, 0.000415, 0))
  cut_feed_jf.sweep_along_path(cut_feed_jf_path)
  trace_res_open_run_path = polyline((0.0004, 0.001765, 0) (0.0004, 0.002915, 0))
  trace_res_open_run [copper] = polyline((0.000392, 0.001765, 0) (0.000408, 0.001765, 0))
  trace_res_open_run.sweep_along_path(trace_res_open_run_path)
  cut_res_open_run_path = polyline((0.0004, 0.001765, 0) (0.0004, 0.002915, 0))
  cut_res_open_run = polyline((0.000383, 0.001765, 0) (0.000417, 0.001765, 0))
  cut_res_open_run.sweep_along_path(cut_res_open_run_path)
  trace_filter_tail_path = polyline(z=0, xy: (0, 0.001765) (0, 0.002165) (-0.0004, 0.002165) (-0.0004, 0.00065) (-0.0008, 0.00065) (-0.0008, 0.0012909213))
  trace_filter_tail_path.fillet(Vertices=trace_filter_tail_path.vertex(2 of 6, 3 of 6, 4 of 6, 5 of 6) Radius=9.9e-05 Setback=0mm)
  trace_filter_tail [copper] = polyline((-8e-06, 0.001765, 0) (8e-06, 0.001765, 0))
  trace_filter_tail.sweep_along_path(trace_filter_tail_path)
  cut_filter_tail_path = polyline(z=0, xy: (0, 0.001765) (0, 0.002165) (-0.0004, 0.002165) (-0.0004, 0.00065) (-0.0008, 0.00065) (-0.0008, 0.0012909213))
  cut_filter_tail_path.fillet(Vertices=cut_filter_tail_path.vertex(2 of 6, 3 of 6, 4 of 6, 5 of 6) Radius=9.9e-05 Setback=0mm)
  cut_filter_tail = polyline((-1.7e-05, 0.001765, 0) (1.7e-05, 0.001765, 0))
  cut_filter_tail.sweep_along_path(cut_filter_tail_path)
  trace_res_tail_path = polyline(z=0, xy: (0.0004, 0.001465) (0.0004, 0.00065) (0.0008, 0.00065) (0.0008, 0.0029225638))
  trace_res_tail_path.fillet(Vertices=trace_res_tail_path.vertex(2 of 4, 3 of 4) Radius=9.9e-05 Setback=0mm)
  trace_res_tail [copper] = polyline((0.000408, 0.001465, 0) (0.000392, 0.001465, 0))
  trace_res_tail.sweep_along_path(trace_res_tail_path)
  cut_res_tail_path = polyline(z=0, xy: (0.0004, 0.001465) (0.0004, 0.00065) (0.0008, 0.00065) (0.0008, 0.0029225638))
  cut_res_tail_path.fillet(Vertices=cut_res_tail_path.vertex(2 of 4, 3 of 4) Radius=9.9e-05 Setback=0mm)
  cut_res_tail = polyline((0.000417, 0.001465, 0) (0.000383, 0.001465, 0))
  cut_res_tail.sweep_along_path(cut_res_tail_path)
  g_wb [pec] = bondwire(WireType=LOW WireDiameter=0.015mm NumSides=6 XPadPos=-0.0013441667 YPadPos=-3.4e-05 ZPadPos=0 XDir=0 YDir=1 ZDir=0 Distance=6.8e-05 h1=6.8e-05 h2=0mm alpha=80deg beta=80deg WhichAxis=Z)
  g_wb_1 [pec] = bondwire(WireType=LOW WireDiameter=0.015mm NumSides=6 XPadPos=-0.0010683333 YPadPos=-3.4e-05 ZPadPos=0 XDir=0 YDir=1 ZDir=0 Distance=6.8e-05 h1=6.8e-05 h2=0mm alpha=80deg beta=80deg WhichAxis=Z)
  g_wb_2 [pec] = bondwire(WireType=LOW WireDiameter=0.015mm NumSides=6 XPadPos=-0.00033875 YPadPos=-3.4e-05 ZPadPos=0 XDir=0 YDir=1 ZDir=0 Distance=6.8e-05 h1=6.8e-05 h2=0mm alpha=80deg beta=80deg WhichAxis=Z)
  g_wb_3 [pec] = bondwire(WireType=LOW WireDiameter=0.015mm NumSides=6 XPadPos=0.000444 YPadPos=-3.4e-05 ZPadPos=0 XDir=0 YDir=1 ZDir=0 Distance=6.8e-05 h1=6.8e-05 h2=0mm alpha=80deg beta=80deg WhichAxis=Z)
  g_wb_4 [pec] = bondwire(WireType=LOW WireDiameter=0.015mm NumSides=6 XPadPos=0.000738 YPadPos=-3.4e-05 ZPadPos=0 XDir=0 YDir=1 ZDir=0 Distance=6.8e-05 h1=6.8e-05 h2=0mm alpha=80deg beta=80deg WhichAxis=Z)
  g_wb_5 [pec] = bondwire(WireType=LOW WireDiameter=0.015mm NumSides=6 XPadPos=0.001032 YPadPos=-3.4e-05 ZPadPos=0 XDir=0 YDir=1 ZDir=0 Distance=6.8e-05 h1=6.8e-05 h2=0mm alpha=80deg beta=80deg WhichAxis=Z)
  g_wb_6 [pec] = bondwire(WireType=LOW WireDiameter=0.015mm NumSides=6 XPadPos=0.001326 YPadPos=-3.4e-05 ZPadPos=0 XDir=0 YDir=1 ZDir=0 Distance=6.8e-05 h1=6.8e-05 h2=0mm alpha=80deg beta=80deg WhichAxis=Z)
  g_wb_7 [pec] = bondwire(WireType=LOW WireDiameter=0.015mm NumSides=6 XPadPos=3.4e-05 YPadPos=0.0006775 ZPadPos=0 XDir=-1 YDir=0 ZDir=0 Distance=6.8e-05 h1=6.8e-05 h2=0mm alpha=80deg beta=80deg WhichAxis=Z)
  g_wb_8 [pec] = bondwire(WireType=LOW WireDiameter=0.015mm NumSides=6 XPadPos=3.4e-05 YPadPos=0.00094 ZPadPos=0 XDir=-1 YDir=0 ZDir=0 Distance=6.8e-05 h1=6.8e-05 h2=0mm alpha=80deg beta=80deg WhichAxis=Z)
  g_wb_9 [pec] = bondwire(WireType=LOW WireDiameter=0.015mm NumSides=6 XPadPos=3.4e-05 YPadPos=0.0012025 ZPadPos=0 XDir=-1 YDir=0 ZDir=0 Distance=6.8e-05 h1=6.8e-05 h2=0mm alpha=80deg beta=80deg WhichAxis=Z)
  g_wb_10 [pec] = bondwire(WireType=LOW WireDiameter=0.015mm NumSides=6 XPadPos=0.000434 YPadPos=0.0020525 ZPadPos=0 XDir=-1 YDir=0 ZDir=0 Distance=6.8e-05 h1=6.8e-05 h2=0mm alpha=80deg beta=80deg WhichAxis=Z)
  g_wb_11 [pec] = bondwire(WireType=LOW WireDiameter=0.015mm NumSides=6 XPadPos=0.000434 YPadPos=0.00234 ZPadPos=0 XDir=-1 YDir=0 ZDir=0 Distance=6.8e-05 h1=6.8e-05 h2=0mm alpha=80deg beta=80deg WhichAxis=Z)
  g_wb_12 [pec] = bondwire(WireType=LOW WireDiameter=0.015mm NumSides=6 XPadPos=0.000434 YPadPos=0.0026275 ZPadPos=0 XDir=-1 YDir=0 ZDir=0 Distance=6.8e-05 h1=6.8e-05 h2=0mm alpha=80deg beta=80deg WhichAxis=Z)
  g_wb_13 [pec] = bondwire(WireType=LOW WireDiameter=0.015mm NumSides=6 XPadPos=3.4e-05 YPadPos=0.001965 ZPadPos=0 XDir=-1 YDir=0 ZDir=0 Distance=6.8e-05 h1=6.8e-05 h2=0mm alpha=80deg beta=80deg WhichAxis=Z)
  g_wb_14 [pec] = bondwire(WireType=LOW WireDiameter=0.015mm NumSides=6 XPadPos=-0.0002 YPadPos=0.002199 ZPadPos=0 XDir=0 YDir=-1 ZDir=0 Distance=6.8e-05 h1=6.8e-05 h2=0mm alpha=80deg beta=80deg WhichAxis=Z)
  g_wb_15 [pec] = bondwire(WireType=LOW WireDiameter=0.015mm NumSides=6 XPadPos=-0.000434 YPadPos=0.001862 ZPadPos=0 XDir=1 YDir=0 ZDir=0 Distance=6.8e-05 h1=6.8e-05 h2=0mm alpha=80deg beta=80deg WhichAxis=Z)
  g_wb_16 [pec] = bondwire(WireType=LOW WireDiameter=0.015mm NumSides=6 XPadPos=-0.000434 YPadPos=0.001559 ZPadPos=0 XDir=1 YDir=0 ZDir=0 Distance=6.8e-05 h1=6.8e-05 h2=0mm alpha=80deg beta=80deg WhichAxis=Z)
  g_wb_17 [pec] = bondwire(WireType=LOW WireDiameter=0.015mm NumSides=6 XPadPos=-0.000434 YPadPos=0.001256 ZPadPos=0 XDir=1 YDir=0 ZDir=0 Distance=6.8e-05 h1=6.8e-05 h2=0mm alpha=80deg beta=80deg WhichAxis=Z)
  g_wb_18 [pec] = bondwire(WireType=LOW WireDiameter=0.015mm NumSides=6 XPadPos=-0.000434 YPadPos=0.000953 ZPadPos=0 XDir=1 YDir=0 ZDir=0 Distance=6.8e-05 h1=6.8e-05 h2=0mm alpha=80deg beta=80deg WhichAxis=Z)
  g_wb_19 [pec] = bondwire(WireType=LOW WireDiameter=0.015mm NumSides=6 XPadPos=-0.0006 YPadPos=0.000684 ZPadPos=0 XDir=0 YDir=-1 ZDir=0 Distance=6.8e-05 h1=6.8e-05 h2=0mm alpha=80deg beta=80deg WhichAxis=Z)
  g_wb_20 [pec] = bondwire(WireType=LOW WireDiameter=0.015mm NumSides=6 XPadPos=-0.000766 YPadPos=0.00097046066 ZPadPos=0 XDir=-1 YDir=0 ZDir=0 Distance=6.8e-05 h1=6.8e-05 h2=0mm alpha=80deg beta=80deg WhichAxis=Z)
  g_wb_21 [pec] = bondwire(WireType=LOW WireDiameter=0.015mm NumSides=6 XPadPos=0.000366 YPadPos=0.0011933333 ZPadPos=0 XDir=1 YDir=0 ZDir=0 Distance=6.8e-05 h1=6.8e-05 h2=0mm alpha=80deg beta=80deg WhichAxis=Z)
  g_wb_22 [pec] = bondwire(WireType=LOW WireDiameter=0.015mm NumSides=6 XPadPos=0.000366 YPadPos=0.00092166667 ZPadPos=0 XDir=1 YDir=0 ZDir=0 Distance=6.8e-05 h1=6.8e-05 h2=0mm alpha=80deg beta=80deg WhichAxis=Z)
  g_wb_23 [pec] = bondwire(WireType=LOW WireDiameter=0.015mm NumSides=6 XPadPos=0.0006 YPadPos=0.000616 ZPadPos=0 XDir=0 YDir=1 ZDir=0 Distance=6.8e-05 h1=6.8e-05 h2=0mm alpha=80deg beta=80deg WhichAxis=Z)
  g_wb_24 [pec] = bondwire(WireType=LOW WireDiameter=0.015mm NumSides=6 XPadPos=0.000834 YPadPos=0.00097465197 ZPadPos=0 XDir=-1 YDir=0 ZDir=0 Distance=6.8e-05 h1=6.8e-05 h2=0mm alpha=80deg beta=80deg WhichAxis=Z)
  g_wb_25 [pec] = bondwire(WireType=LOW WireDiameter=0.015mm NumSides=6 XPadPos=0.000834 YPadPos=0.0012993039 ZPadPos=0 XDir=-1 YDir=0 ZDir=0 Distance=6.8e-05 h1=6.8e-05 h2=0mm alpha=80deg beta=80deg WhichAxis=Z)
  g_wb_26 [pec] = bondwire(WireType=LOW WireDiameter=0.015mm NumSides=6 XPadPos=0.000834 YPadPos=0.0016239559 ZPadPos=0 XDir=-1 YDir=0 ZDir=0 Distance=6.8e-05 h1=6.8e-05 h2=0mm alpha=80deg beta=80deg WhichAxis=Z)
  g_wb_27 [pec] = bondwire(WireType=LOW WireDiameter=0.015mm NumSides=6 XPadPos=0.000834 YPadPos=0.0019486079 ZPadPos=0 XDir=-1 YDir=0 ZDir=0 Distance=6.8e-05 h1=6.8e-05 h2=0mm alpha=80deg beta=80deg WhichAxis=Z)
  g_wb_28 [pec] = bondwire(WireType=LOW WireDiameter=0.015mm NumSides=6 XPadPos=0.000834 YPadPos=0.0022732598 ZPadPos=0 XDir=-1 YDir=0 ZDir=0 Distance=6.8e-05 h1=6.8e-05 h2=0mm alpha=80deg beta=80deg WhichAxis=Z)
  g_wb_29 [pec] = bondwire(WireType=LOW WireDiameter=0.015mm NumSides=6 XPadPos=0.000834 YPadPos=0.0025979118 ZPadPos=0 XDir=-1 YDir=0 ZDir=0 Distance=6.8e-05 h1=6.8e-05 h2=0mm alpha=80deg beta=80deg WhichAxis=Z)
  launch_pad_LPPin [copper] = polyline(z=0, xy: (-0.00165, 8e-06) (-0.001772, 0.0001) (-0.001972, 0.0001) (-0.001972, -0.0001) (-0.001772, -0.0001) (-0.00165, -8e-06) (-0.00162, -8e-06) (-0.00162, 8e-06) (-0.00165, 8e-06), closed, covered)
  pocket_LPPin = polyline(z=0, xy: (-0.00165, 1.7e-05) (-0.001772, 0.0001765) (-0.0020485, 0.0001765) (-0.0020485, -0.0001765) (-0.001772, -0.0001765) (-0.00165, -1.7e-05) (-0.00162, -1.7e-05) (-0.00162, 1.7e-05) (-0.00165, 1.7e-05), closed, covered)
  launch_pad_LPPout [copper] = polyline(z=0, xy: (0.00165, -8e-06) (0.001772, -0.0001) (0.001972, -0.0001) (0.001972, 0.0001) (0.001772, 0.0001) (0.00165, 8e-06) (0.00162, 8e-06) (0.00162, -8e-06) (0.00165, -8e-06), closed, covered)
  pocket_LPPout = polyline(z=0, xy: (0.00165, -1.7e-05) (0.001772, -0.0001765) (0.0020485, -0.0001765) (0.0020485, 0.0001765) (0.001772, 0.0001765) (0.00165, 1.7e-05) (0.00162, 1.7e-05) (0.00162, -1.7e-05) (0.00165, -1.7e-05), closed, covered)
  plate_cin [copper] = polyline(z=0, xy: (-0.0006725, -9.5e-05) (-0.00067328414, -9.4961478e-05) (-0.00067406072, -9.4846282e-05) (-0.00067482228, -9.4655523e-05) (-0.00067556147, -9.4391036e-05) (-0.00067627117, -9.405537e-05) (-0.00067694456, -9.3651757e-05) (-0.00067757515, -9.3184084e-05) (-0.00067815685, -9.2656854e-05) (-0.00067868408, -9.2075146e-05) (-0.00067915176, -9.1444562e-05) (-0.00067955537, -9.0771174e-05) (-0.00067989104, -9.0061467e-05) (-0.00068015552, -8.9322277e-05) (-0.00068034628, -8.8560723e-05) (-0.00068046148, -8.7784137e-05) (-0.0006805, -8.7e-05) (-0.0006805, 8.7e-05) (-0.00068046148, 8.7784137e-05) (-0.00068034628, 8.8560723e-05) (-0.00068015552, 8.9322277e-05) (-0.00067989104, 9.0061467e-05) (-0.00067955537, 9.0771174e-05) (-0.00067915176, 9.1444562e-05) (-0.00067868408, 9.2075146e-05) (-0.00067815685, 9.2656854e-05) (-0.00067757515, 9.3184084e-05) (-0.00067694456, 9.3651757e-05) (-0.00067627117, 9.405537e-05) (-0.00067556147, 9.4391036e-05) (-0.00067482228, 9.4655523e-05) (-0.00067406072, 9.4846282e-05) (-0.00067328414, 9.4961478e-05) (-0.0006725, 9.5e-05) (-0.0006475, 9.5e-05) (-0.00064671586, 9.4961478e-05) (-0.00064593928, 9.4846282e-05) (-0.00064517772, 9.4655523e-05) (-0.00064443853, 9.4391036e-05) (-0.00064372883, 9.405537e-05) (-0.00064305544, 9.3651757e-05) (-0.00064242485, 9.3184084e-05) (-0.00064184315, 9.2656854e-05) (-0.00064131592, 9.2075146e-05) (-0.00064084824, 9.1444562e-05) (-0.00064044463, 9.0771174e-05) (-0.00064010896, 9.0061467e-05) (-0.00063984448, 8.9322277e-05) (-0.00063965372, 8.8560723e-05) (-0.00063953852, 8.7784137e-05) (-0.0006395, 8.7e-05) (-0.0006395, -8.7e-05) (-0.00063953852, -8.7784137e-05) (-0.00063965372, -8.8560723e-05) (-0.00063984448, -8.9322277e-05) (-0.00064010896, -9.0061467e-05) (-0.00064044463, -9.0771174e-05) (-0.00064084824, -9.1444562e-05) (-0.00064131592, -9.2075146e-05) (-0.00064184315, -9.2656854e-05) (-0.00064242485, -9.3184084e-05) (-0.00064305544, -9.3651757e-05) (-0.00064372883, -9.405537e-05) (-0.00064443853, -9.4391036e-05) (-0.00064517772, -9.4655523e-05) (-0.00064593928, -9.4846282e-05) (-0.00064671586, -9.4961478e-05) (-0.0006475, -9.5e-05) (-0.0006725, -9.5e-05), closed, covered)
  frame_cin [copper] = polyline(z=0, xy: (-0.0006925, -9.9e-05) (-0.00069246148, -9.9784137e-05) (-0.00069234628, -0.00010056072) (-0.00069215552, -0.00010132228) (-0.00069189104, -0.00010206147) (-0.00069155537, -0.00010277117) (-0.00069115176, -0.00010344456) (-0.00069068408, -0.00010407515) (-0.00069015685, -0.00010465685) (-0.00068957515, -0.00010518408) (-0.00068894456, -0.00010565176) (-0.00068827117, -0.00010605537) (-0.00068756147, -0.00010639104) (-0.00068682228, -0.00010665552) (-0.00068606072, -0.00010684628) (-0.00068528414, -0.00010696148) (-0.0006845, -0.000107) (-0.0006355, -0.000107) (-0.00063471586, -0.00010696148) (-0.00063393928, -0.00010684628) (-0.00063317772, -0.00010665552) (-0.00063243853, -0.00010639104) (-0.00063172883, -0.00010605537) (-0.00063105544, -0.00010565176) (-0.00063042485, -0.00010518408) (-0.00062984315, -0.00010465685) (-0.00062931592, -0.00010407515) (-0.00062884824, -0.00010344456) (-0.00062844463, -0.00010277117) (-0.00062810896, -0.00010206147) (-0.00062784448, -0.00010132228) (-0.00062765372, -0.00010056072) (-0.00062753852, -9.9784137e-05) (-0.0006275, -9.9e-05) (-0.0006275, -2.509818e-05) (-0.00062749518, -2.4901939e-05) (-0.00062747111, -2.4412015e-05) (-0.00062743266, -2.40216e-05) (-0.0006273751, -2.3633541e-05) (-0.00062729856, -2.3248774e-05) (-0.00062720324, -2.2868226e-05) (-0.00062708936, -2.2492814e-05) (-0.0006269572, -2.2123441e-05) (-0.00062680707, -2.1760999e-05) (-0.00062663934, -2.140636e-05) (-0.00062645441, -2.1060378e-05) (-0.00062625272, -2.0723887e-05) (-0.00062603477, -2.0397697e-05) (-0.00062580107, -2.0082595e-05) (-0.0006255522, -1.9779339e-05) (-0.00062528874, -1.948866e-05) (-0.00062501134, -1.9211259e-05) (-0.00062472066, -1.8947803e-05) (-0.0006244174, -1.8698928e-05) (-0.0006241023, -1.8465232e-05) (-0.00062377611, -1.8247279e-05) (-0.00062343962, -1.8045594e-05) (-0.00062309364, -1.7860663e-05) (-0.000622739, -1.7692931e-05) (-0.00062237656, -1.7542802e-05) (-0.00062200719, -1.7410639e-05) (-0.00062163177, -1.7296759e-05) (-0.00062125123, -1.7201436e-05) (-0.00062086646, -1.7124902e-05) (-0.0006204784, -1.7067338e-05) (-0.00062008799, -1.7028886e-05) (-0.00061959806, -1.7004817e-05) (-0.00061940182, -1.7e-05) (-0.00057559818, -1.7e-05) (-0.00057540194, -1.7004817e-05) (-0.00057491201, -1.7028886e-05) (-0.0005745216, -1.7067338e-05) (-0.00057413354, -1.7124902e-05) (-0.00057374877, -1.7201436e-05) (-0.00057336823, -1.7296759e-05) (-0.00057299281, -1.7410639e-05) (-0.00057262344, -1.7542802e-05) (-0.000572261, -1.7692931e-05) (-0.00057190636, -1.7860663e-05) (-0.00057156038, -1.8045594e-05) (-0.00057122389, -1.8247279e-05) (-0.0005708977, -1.8465232e-05) (-0.0005705826, -1.8698928e-05) (-0.00057027934, -1.8947803e-05) (-0.00056998866, -1.9211259e-05) (-0.00056971126, -1.948866e-05) (-0.0005694478, -1.9779339e-05) (-0.00056919893, -2.0082595e-05) (-0.00056896523, -2.0397697e-05) (-0.00056874728, -2.0723887e-05) (-0.00056854559, -2.1060378e-05) (-0.00056836066, -2.140636e-05) (-0.00056819293, -2.1760999e-05) (-0.0005680428, -2.2123441e-05) (-0.00056791064, -2.2492814e-05) (-0.00056779676, -2.2868226e-05) (-0.00056770144, -2.3248774e-05) (-0.0005676249, -2.3633541e-05) (-0.00056756734, -2.40216e-05) (-0.00056752889, -2.4412015e-05) (-0.00056750482, -2.4901939e-05) (-0.0005675, -2.509818e-05) (-0.0005675, -0.00015590182) (-0.00056750482, -0.00015609806) (-0.00056752889, -0.00015658798) (-0.00056756734, -0.0001569784) (-0.0005676249, -0.00015736646) (-0.00056770144, -0.00015775123) (-0.00056779676, -0.00015813177) (-0.00056791064, -0.00015850719) (-0.0005680428, -0.00015887656) (-0.00056819293, -0.000159239) (-0.00056836066, -0.00015959364) (-0.00056854559, -0.00015993962) (-0.00056874728, -0.00016027611) (-0.00056896523, -0.0001606023) (-0.00056919893, -0.00016091741) (-0.0005694478, -0.00016122066) (-0.00056971126, -0.00016151134) (-0.00056998866, -0.00016178874) (-0.00057027934, -0.0001620522) (-0.0005705826, -0.00016230107) (-0.0005708977, -0.00016253477) (-0.00057122389, -0.00016275272) (-0.00057156038, -0.00016295441) (-0.00057190636, -0.00016313934) (-0.000572261, -0.00016330707) (-0.00057262344, -0.0001634572) (-0.00057299281, -0.00016358936) (-0.00057336823, -0.00016370324) (-0.00057374877, -0.00016379856) (-0.00057413354, -0.0001638751) (-0.0005745216, -0.00016393266) (-0.00057491201, -0.00016397111) (-0.00057540194, -0.00016399518) (-0.00057559818, -0.000164) (-0.00073640182, -0.000164) (-0.00073659806, -0.00016399518) (-0.00073708798, -0.00016397111) (-0.0007374784, -0.00016393266) (-0.00073786646, -0.0001638751) (-0.00073825123, -0.00016379856) (-0.00073863177, -0.00016370324) (-0.00073900719, -0.00016358936) (-0.00073937656, -0.0001634572) (-0.000739739, -0.00016330707) (-0.00074009364, -0.00016313934) (-0.00074043962, -0.00016295441) (-0.00074077611, -0.00016275272) (-0.0007411023, -0.00016253477) (-0.0007414174, -0.00016230107) (-0.00074172066, -0.0001620522) (-0.00074201134, -0.00016178874) (-0.00074228874, -0.00016151134) (-0.0007425522, -0.00016122066) (-0.00074280107, -0.00016091741) (-0.00074303477, -0.0001606023) (-0.00074325272, -0.00016027611) (-0.00074345441, -0.00015993962) (-0.00074363934, -0.00015959364) (-0.00074380707, -0.000159239) (-0.0007439572, -0.00015887656) (-0.00074408936, -0.00015850719) (-0.00074420324, -0.00015813177) (-0.00074429856, -0.00015775123) (-0.0007443751, -0.00015736646) (-0.00074443266, -0.0001569784) (-0.00074447111, -0.00015658798) (-0.00074449518, -0.00015609806) (-0.0007445, -0.00015590182) (-0.0007445, 0.00015590182) (-0.00074449518, 0.00015609806) (-0.00074447111, 0.00015658798) (-0.00074443266, 0.0001569784) (-0.0007443751, 0.00015736646) (-0.00074429856, 0.00015775123) (-0.00074420324, 0.00015813177) (-0.00074408936, 0.00015850719) (-0.0007439572, 0.00015887656) (-0.00074380707, 0.000159239) (-0.00074363934, 0.00015959364) (-0.00074345441, 0.00015993962) (-0.00074325272, 0.00016027611) (-0.00074303477, 0.0001606023) (-0.00074280107, 0.00016091741) (-0.0007425522, 0.00016122066) (-0.00074228874, 0.00016151134) (-0.00074201134, 0.00016178874) (-0.00074172066, 0.0001620522) (-0.0007414174, 0.00016230107) (-0.0007411023, 0.00016253477) (-0.00074077611, 0.00016275272) (-0.00074043962, 0.00016295441) (-0.00074009364, 0.00016313934) (-0.000739739, 0.00016330707) (-0.00073937656, 0.0001634572) (-0.00073900719, 0.00016358936) (-0.00073863177, 0.00016370324) (-0.00073825123, 0.00016379856) (-0.00073786646, 0.0001638751) (-0.0007374784, 0.00016393266) (-0.00073708798, 0.00016397111) (-0.00073659806, 0.00016399518) (-0.00073640182, 0.000164) (-0.00057559818, 0.000164) (-0.00057540194, 0.00016399518) (-0.00057491201, 0.00016397111) (-0.0005745216, 0.00016393266) (-0.00057413354, 0.0001638751) (-0.00057374877, 0.00016379856) (-0.00057336823, 0.00016370324) (-0.00057299281, 0.00016358936) (-0.00057262344, 0.0001634572) (-0.000572261, 0.00016330707) (-0.00057190636, 0.00016313934) (-0.00057156038, 0.00016295441) (-0.00057122389, 0.00016275272) (-0.0005708977, 0.00016253477) (-0.0005705826, 0.00016230107) (-0.00057027934, 0.0001620522) (-0.00056998866, 0.00016178874) (-0.00056971126, 0.00016151134) (-0.0005694478, 0.00016122066) (-0.00056919893, 0.00016091741) (-0.00056896523, 0.0001606023) (-0.00056874728, 0.00016027611) (-0.00056854559, 0.00015993962) (-0.00056836066, 0.00015959364) (-0.00056819293, 0.000159239) (-0.0005680428, 0.00015887656) (-0.00056791064, 0.00015850719) (-0.00056779676, 0.00015813177) (-0.00056770144, 0.00015775123) (-0.0005676249, 0.00015736646) (-0.00056756734, 0.0001569784) (-0.00056752889, 0.00015658798) (-0.00056750482, 0.00015609806) (-0.0005675, 0.00015590182) (-0.0005675, 2.509818e-05) (-0.00056750482, 2.4901939e-05) (-0.00056752889, 2.4412015e-05) (-0.00056756734, 2.40216e-05) (-0.0005676249, 2.3633541e-05) (-0.00056770144, 2.3248774e-05) (-0.00056779676, 2.2868226e-05) (-0.00056791064, 2.2492814e-05) (-0.0005680428, 2.2123441e-05) (-0.00056819293, 2.1760999e-05) (-0.00056836066, 2.140636e-05) (-0.00056854559, 2.1060378e-05) (-0.00056874728, 2.0723887e-05) (-0.00056896523, 2.0397697e-05) (-0.00056919893, 2.0082595e-05) (-0.0005694478, 1.9779339e-05) (-0.00056971126, 1.948866e-05) (-0.00056998866, 1.9211259e-05) (-0.00057027934, 1.8947803e-05) (-0.0005705826, 1.8698928e-05) (-0.0005708977, 1.8465232e-05) (-0.00057122389, 1.8247279e-05) (-0.00057156038, 1.8045594e-05) (-0.00057190636, 1.7860663e-05) (-0.000572261, 1.7692931e-05) (-0.00057262344, 1.7542802e-05) (-0.00057299281, 1.7410639e-05) (-0.00057336823, 1.7296759e-05) (-0.00057374877, 1.7201436e-05) (-0.00057413354, 1.7124902e-05) (-0.0005745216, 1.7067338e-05) (-0.00057491201, 1.7028886e-05) (-0.00057540194, 1.7004817e-05) (-0.00057559818, 1.7e-05) (-0.00061940182, 1.7e-05) (-0.00061959806, 1.7004817e-05) (-0.00062008799, 1.7028886e-05) (-0.0006204784, 1.7067338e-05) (-0.00062086646, 1.7124902e-05) (-0.00062125123, 1.7201436e-05) (-0.00062163177, 1.7296759e-05) (-0.00062200719, 1.7410639e-05) (-0.00062237656, 1.7542802e-05) (-0.000622739, 1.7692931e-05) (-0.00062309364, 1.7860663e-05) (-0.00062343962, 1.8045594e-05) (-0.00062377611, 1.8247279e-05) (-0.0006241023, 1.8465232e-05) (-0.0006244174, 1.8698928e-05) (-0.00062472066, 1.8947803e-05) (-0.00062501134, 1.9211259e-05) (-0.00062528874, 1.948866e-05) (-0.0006255522, 1.9779339e-05) (-0.00062580107, 2.0082595e-05) (-0.00062603477, 2.0397697e-05) (-0.00062625272, 2.0723887e-05) (-0.00062645441, 2.1060378e-05) (-0.00062663934, 2.140636e-05) (-0.00062680707, 2.1760999e-05) (-0.0006269572, 2.2123441e-05) (-0.00062708936, 2.2492814e-05) (-0.00062720324, 2.2868226e-05)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, closed, covered)
  pocket_cin = polyline(z=0, xy: (-0.0007565, -0.000164) (-0.0007565, 0.000164) (-0.00075644222, 0.00016517621) (-0.00075626942, 0.00016634108) (-0.00075598328, 0.00016748342) (-0.00075558655, 0.0001685922) (-0.00075508306, 0.00016965676) (-0.00075447763, 0.00017066684) (-0.00075377612, 0.00017161272) (-0.00075298528, 0.00017248528) (-0.00075211272, 0.00017327613) (-0.00075116684, 0.00017397764) (-0.00075015676, 0.00017458305) (-0.0007490922, 0.00017508655) (-0.00074798342, 0.00017548328) (-0.00074684108, 0.00017576942) (-0.00074567621, 0.00017594222) (-0.0007445, 0.000176) (-0.0005675, 0.000176) (-0.00056632379, 0.00017594222) (-0.00056515892, 0.00017576942) (-0.00056401658, 0.00017548328) (-0.0005629078, 0.00017508655) (-0.00056184324, 0.00017458305) (-0.00056083316, 0.00017397764) (-0.00055988728, 0.00017327613) (-0.00055901472, 0.00017248528) (-0.00055822388, 0.00017161272) (-0.00055752237, 0.00017066684) (-0.00055691694, 0.00016965676) (-0.00055641345, 0.0001685922) (-0.00055601672, 0.00016748342) (-0.00055573058, 0.00016634108) (-0.00055555778, 0.00016517621) (-0.0005555, 0.000164) (-0.0005555, -0.000164) (-0.00055555778, -0.00016517621) (-0.00055573058, -0.00016634108) (-0.00055601672, -0.00016748342) (-0.00055641345, -0.0001685922) (-0.00055691694, -0.00016965676) (-0.00055752237, -0.00017066684) (-0.00055822388, -0.00017161272) (-0.00055901472, -0.00017248528) (-0.00055988728, -0.00017327613) (-0.00056083316, -0.00017397764) (-0.00056184324, -0.00017458305) (-0.0005629078, -0.00017508655) (-0.00056401658, -0.00017548328) (-0.00056515892, -0.00017576942) (-0.00056632379, -0.00017594222) (-0.0005675, -0.000176) (-0.0007445, -0.000176) (-0.00074567621, -0.00017594222) (-0.00074684108, -0.00017576942) (-0.00074798342, -0.00017548328) (-0.0007490922, -0.00017508655) (-0.00075015676, -0.00017458305) (-0.00075116684, -0.00017397764) (-0.00075211272, -0.00017327613) (-0.00075298528, -0.00017248528) (-0.00075377612, -0.00017161272) (-0.00075447763, -0.00017066684) (-0.00075508306, -0.00016965676) (-0.00075558655, -0.0001685922) (-0.00075598328, -0.00016748342) (-0.00075626942, -0.00016634108) (-0.00075644222, -0.00016517621) (-0.0007565, -0.000164), closed, covered)
  tap_trace_n0 [copper] = polyline(z=0, xy: (0.00015, -8e-06) (-0.00015, -8e-06) (-0.00015, 8e-06) (-8e-06, 8e-06) (-8e-06, 0.0001) (8e-06, 0.0001) (8e-06, 8e-06) (0.00015, 8e-06) (0.00015, -8e-06), closed, covered)
  tap_cut_n0 = polyline(z=0, xy: (0.00015, -1.7e-05) (-0.00015, -1.7e-05) (-0.00015, 1.7e-05) (-1.7e-05, 1.7e-05) (-1.7e-05, 0.0001) (1.7e-05, 0.0001) (1.7e-05, 1.7e-05) (0.00015, 1.7e-05) (0.00015, -1.7e-05), closed, covered)
  plate_cp [copper] = polyline(z=0, xy: (9.5e-05, 0.00027) (9.4961478e-05, 0.00026921586) (9.4846282e-05, 0.00026843928) (9.4655523e-05, 0.00026767772) (9.4391036e-05, 0.00026693853) (9.405537e-05, 0.00026622883) (9.3651757e-05, 0.00026555544) (9.3184084e-05, 0.00026492485) (9.2656854e-05, 0.00026434315) (9.2075146e-05, 0.00026381592) (9.1444562e-05, 0.00026334824) (9.0771174e-05, 0.00026294463) (9.0061467e-05, 0.00026260896) (8.9322277e-05, 0.00026234448) (8.8560723e-05, 0.00026215372) (8.7784137e-05, 0.00026203852) (8.7e-05, 0.000262) (-8.7e-05, 0.000262) (-8.7784137e-05, 0.00026203852) (-8.8560723e-05, 0.00026215372) (-8.9322277e-05, 0.00026234448) (-9.0061467e-05, 0.00026260896) (-9.0771174e-05, 0.00026294463) (-9.1444562e-05, 0.00026334824) (-9.2075146e-05, 0.00026381592) (-9.2656854e-05, 0.00026434315) (-9.3184084e-05, 0.00026492485) (-9.3651757e-05, 0.00026555544) (-9.405537e-05, 0.00026622883) (-9.4391036e-05, 0.00026693853) (-9.4655523e-05, 0.00026767772) (-9.4846282e-05, 0.00026843928) (-9.4961478e-05, 0.00026921586) (-9.5e-05, 0.00027) (-9.5e-05, 0.000295) (-9.4961478e-05, 0.00029578414) (-9.4846282e-05, 0.00029656072) (-9.4655523e-05, 0.00029732228) (-9.4391036e-05, 0.00029806147) (-9.405537e-05, 0.00029877117) (-9.3651757e-05, 0.00029944456) (-9.3184084e-05, 0.00030007515) (-9.2656854e-05, 0.00030065685) (-9.2075146e-05, 0.00030118408) (-9.1444562e-05, 0.00030165176) (-9.0771174e-05, 0.00030205537) (-9.0061467e-05, 0.00030239104) (-8.9322277e-05, 0.00030265552) (-8.8560723e-05, 0.00030284628) (-8.7784137e-05, 0.00030296148) (-8.7e-05, 0.000303) (8.7e-05, 0.000303) (8.7784137e-05, 0.00030296148) (8.8560723e-05, 0.00030284628) (8.9322277e-05, 0.00030265552) (9.0061467e-05, 0.00030239104) (9.0771174e-05, 0.00030205537) (9.1444562e-05, 0.00030165176) (9.2075146e-05, 0.00030118408) (9.2656854e-05, 0.00030065685) (9.3184084e-05, 0.00030007515) (9.3651757e-05, 0.00029944456) (9.405537e-05, 0.00029877117) (9.4391036e-05, 0.00029806147) (9.4655523e-05, 0.00029732228) (9.4846282e-05, 0.00029656072) (9.4961478e-05, 0.00029578414) (9.5e-05, 0.000295) (9.5e-05, 0.00027), closed, covered)
  frame_cp [copper] = polyline(z=0, xy: (9.9e-05, 0.00025) (9.9784137e-05, 0.00025003852) (0.00010056072, 0.00025015372) (0.00010132228, 0.00025034448) (0.00010206147, 0.00025060896) (0.00010277117, 0.00025094463) (0.00010344456, 0.00025134824) (0.00010407515, 0.00025181592) (0.00010465685, 0.00025234315) (0.00010518408, 0.00025292485) (0.00010565176, 0.00025355544) (0.00010605537, 0.00025422883) (0.00010639104, 0.00025493853) (0.00010665552, 0.00025567772) (0.00010684628, 0.00025643928) (0.00010696148, 0.00025721586) (0.000107, 0.000258) (0.000107, 0.000307) (0.00010696148, 0.00030778414) (0.00010684628, 0.00030856072) (0.00010665552, 0.00030932228) (0.00010639104, 0.00031006147) (0.00010605537, 0.00031077117) (0.00010565176, 0.00031144456) (0.00010518408, 0.00031207515) (0.00010465685, 0.00031265685) (0.00010407515, 0.00031318408) (0.00010344456, 0.00031365176) (0.00010277117, 0.00031405537) (0.00010206147, 0.00031439104) (0.00010132228, 0.00031465552) (0.00010056072, 0.00031484628) (9.9784137e-05, 0.00031496148) (9.9e-05, 0.000315) (2.509818e-05, 0.000315) (2.4901939e-05, 0.00031500482) (2.4412015e-05, 0.00031502889) (2.40216e-05, 0.00031506734) (2.3633541e-05, 0.0003151249) (2.3248774e-05, 0.00031520144) (2.2868226e-05, 0.00031529676) (2.2492814e-05, 0.00031541064) (2.2123441e-05, 0.0003155428) (2.1760999e-05, 0.00031569293) (2.140636e-05, 0.00031586066) (2.1060378e-05, 0.00031604559) (2.0723887e-05, 0.00031624728) (2.0397697e-05, 0.00031646523) (2.0082595e-05, 0.00031669893) (1.9779339e-05, 0.0003169478) (1.948866e-05, 0.00031721126) (1.9211259e-05, 0.00031748866) (1.8947803e-05, 0.00031777934) (1.8698928e-05, 0.00031808259) (1.8465232e-05, 0.0003183977) (1.8247279e-05, 0.00031872389) (1.8045594e-05, 0.00031906038) (1.7860663e-05, 0.00031940636) (1.7692931e-05, 0.000319761) (1.7542802e-05, 0.00032012344) (1.7410639e-05, 0.00032049281) (1.7296759e-05, 0.00032086823) (1.7201436e-05, 0.00032124877) (1.7124902e-05, 0.00032163354) (1.7067338e-05, 0.0003220216) (1.7028886e-05, 0.00032241201) (1.7004817e-05, 0.00032290194) (1.7e-05, 0.00032309818) (1.7e-05, 0.00036690182) (1.7004817e-05, 0.00036709806) (1.7028886e-05, 0.00036758799) (1.7067338e-05, 0.0003679784) (1.7124902e-05, 0.00036836646) (1.7201436e-05, 0.00036875123) (1.7296759e-05, 0.00036913177) (1.7410639e-05, 0.00036950719) (1.7542802e-05, 0.00036987656) (1.7692931e-05, 0.000370239) (1.7860663e-05, 0.00037059364) (1.8045594e-05, 0.00037093962) (1.8247279e-05, 0.00037127611) (1.8465232e-05, 0.0003716023) (1.8698928e-05, 0.0003719174) (1.8947803e-05, 0.00037222066) (1.9211259e-05, 0.00037251134) (1.948866e-05, 0.00037278874) (1.9779339e-05, 0.0003730522) (2.0082595e-05, 0.00037330107) (2.0397697e-05, 0.00037353477) (2.0723887e-05, 0.00037375272) (2.1060378e-05, 0.00037395441) (2.140636e-05, 0.00037413934) (2.1760999e-05, 0.00037430707) (2.2123441e-05, 0.0003744572) (2.2492814e-05, 0.00037458936) (2.2868226e-05, 0.00037470324) (2.3248774e-05, 0.00037479856) (2.3633541e-05, 0.0003748751) (2.40216e-05, 0.00037493266) (2.4412015e-05, 0.00037497111) (2.4901939e-05, 0.00037499518) (2.509818e-05, 0.000375) (0.00015590182, 0.000375) (0.00015609806, 0.00037499518) (0.00015658798, 0.00037497111) (0.0001569784, 0.00037493266) (0.00015736646, 0.0003748751) (0.00015775123, 0.00037479856) (0.00015813177, 0.00037470324) (0.00015850719, 0.00037458936) (0.00015887656, 0.0003744572) (0.000159239, 0.00037430707) (0.00015959364, 0.00037413934) (0.00015993962, 0.00037395441) (0.00016027611, 0.00037375272) (0.0001606023, 0.00037353477) (0.00016091741, 0.00037330107) (0.00016122066, 0.0003730522) (0.00016151134, 0.00037278874) (0.00016178874, 0.00037251134) (0.0001620522, 0.00037222066) (0.00016230107, 0.0003719174) (0.00016253477, 0.0003716023) (0.00016275272, 0.00037127611) (0.00016295441, 0.00037093962) (0.00016313934, 0.00037059364) (0.00016330707, 0.000370239) (0.0001634572, 0.00036987656) (0.00016358936, 0.00036950719) (0.00016370324, 0.00036913177) (0.00016379856, 0.00036875123) (0.0001638751, 0.00036836646) (0.00016393266, 0.0003679784) (0.00016397111, 0.00036758799) (0.00016399518, 0.00036709806) (0.000164, 0.00036690182) (0.000164, 0.00020609818) (0.00016399518, 0.00020590194) (0.00016397111, 0.00020541201) (0.00016393266, 0.0002050216) (0.0001638751, 0.00020463354) (0.00016379856, 0.00020424877) (0.00016370324, 0.00020386823) (0.00016358936, 0.00020349281) (0.0001634572, 0.00020312344) (0.00016330707, 0.000202761) (0.00016313934, 0.00020240636) (0.00016295441, 0.00020206038) (0.00016275272, 0.00020172389) (0.00016253477, 0.0002013977) (0.00016230107, 0.0002010826) (0.0001620522, 0.00020077934) (0.00016178874, 0.00020048866) (0.00016151134, 0.00020021126) (0.00016122066, 0.0001999478) (0.00016091741, 0.00019969893) (0.0001606023, 0.00019946523) (0.00016027611, 0.00019924728) (0.00015993962, 0.00019904559) (0.00015959364, 0.00019886066) (0.000159239, 0.00019869293) (0.00015887656, 0.0001985428) (0.00015850719, 0.00019841064) (0.00015813177, 0.00019829676) (0.00015775123, 0.00019820144) (0.00015736646, 0.0001981249) (0.0001569784, 0.00019806734) (0.00015658798, 0.00019802889) (0.00015609806, 0.00019800482) (0.00015590182, 0.000198) (-0.00015590182, 0.000198) (-0.00015609806, 0.00019800482) (-0.00015658798, 0.00019802889) (-0.0001569784, 0.00019806734) (-0.00015736646, 0.0001981249) (-0.00015775123, 0.00019820144) (-0.00015813177, 0.00019829676) (-0.00015850719, 0.00019841064) (-0.00015887656, 0.0001985428) (-0.000159239, 0.00019869293) (-0.00015959364, 0.00019886066) (-0.00015993962, 0.00019904559) (-0.00016027611, 0.00019924728) (-0.0001606023, 0.00019946523) (-0.00016091741, 0.00019969893) (-0.00016122066, 0.0001999478) (-0.00016151134, 0.00020021126) (-0.00016178874, 0.00020048866) (-0.0001620522, 0.00020077934) (-0.00016230107, 0.0002010826) (-0.00016253477, 0.0002013977) (-0.00016275272, 0.00020172389) (-0.00016295441, 0.00020206038) (-0.00016313934, 0.00020240636) (-0.00016330707, 0.000202761) (-0.0001634572, 0.00020312344) (-0.00016358936, 0.00020349281) (-0.00016370324, 0.00020386823) (-0.00016379856, 0.00020424877) (-0.0001638751, 0.00020463354) (-0.00016393266, 0.0002050216) (-0.00016397111, 0.00020541201) (-0.00016399518, 0.00020590194) (-0.000164, 0.00020609818) (-0.000164, 0.00036690182) (-0.00016399518, 0.00036709806) (-0.00016397111, 0.00036758799) (-0.00016393266, 0.0003679784) (-0.0001638751, 0.00036836646) (-0.00016379856, 0.00036875123) (-0.00016370324, 0.00036913177) (-0.00016358936, 0.00036950719) (-0.0001634572, 0.00036987656) (-0.00016330707, 0.000370239) (-0.00016313934, 0.00037059364) (-0.00016295441, 0.00037093962) (-0.00016275272, 0.00037127611) (-0.00016253477, 0.0003716023) (-0.00016230107, 0.0003719174) (-0.0001620522, 0.00037222066) (-0.00016178874, 0.00037251134) (-0.00016151134, 0.00037278874) (-0.00016122066, 0.0003730522) (-0.00016091741, 0.00037330107) (-0.0001606023, 0.00037353477) (-0.00016027611, 0.00037375272) (-0.00015993962, 0.00037395441) (-0.00015959364, 0.00037413934) (-0.000159239, 0.00037430707) (-0.00015887656, 0.0003744572) (-0.00015850719, 0.00037458936) (-0.00015813177, 0.00037470324) (-0.00015775123, 0.00037479856) (-0.00015736646, 0.0003748751) (-0.0001569784, 0.00037493266) (-0.00015658798, 0.00037497111) (-0.00015609806, 0.00037499518) (-0.00015590182, 0.000375) (-2.509818e-05, 0.000375) (-2.4901939e-05, 0.00037499518) (-2.4412015e-05, 0.00037497111) (-2.40216e-05, 0.00037493266) (-2.3633541e-05, 0.0003748751) (-2.3248774e-05, 0.00037479856) (-2.2868226e-05, 0.00037470324) (-2.2492814e-05, 0.00037458936) (-2.2123441e-05, 0.0003744572) (-2.1760999e-05, 0.00037430707) (-2.140636e-05, 0.00037413934) (-2.1060378e-05, 0.00037395441) (-2.0723887e-05, 0.00037375272) (-2.0397697e-05, 0.00037353477) (-2.0082595e-05, 0.00037330107) (-1.9779339e-05, 0.0003730522) (-1.948866e-05, 0.00037278874) (-1.9211259e-05, 0.00037251134) (-1.8947803e-05, 0.00037222066) (-1.8698928e-05, 0.0003719174) (-1.8465232e-05, 0.0003716023) (-1.8247279e-05, 0.00037127611) (-1.8045594e-05, 0.00037093962) (-1.7860663e-05, 0.00037059364) (-1.7692931e-05, 0.000370239) (-1.7542802e-05, 0.00036987656) (-1.7410639e-05, 0.00036950719) (-1.7296759e-05, 0.00036913177) (-1.7201436e-05, 0.00036875123) (-1.7124902e-05, 0.00036836646) (-1.7067338e-05, 0.0003679784) (-1.7028886e-05, 0.00036758799) (-1.7004817e-05, 0.00036709806) (-1.7e-05, 0.00036690182) (-1.7e-05, 0.00032309818) (-1.7004817e-05, 0.00032290194) (-1.7028886e-05, 0.00032241201) (-1.7067338e-05, 0.0003220216) (-1.7124902e-05, 0.00032163354) (-1.7201436e-05, 0.00032124877) (-1.7296759e-05, 0.00032086823) (-1.7410639e-05, 0.00032049281) (-1.7542802e-05, 0.00032012344) (-1.7692931e-05, 0.000319761) (-1.7860663e-05, 0.00031940636) (-1.8045594e-05, 0.00031906038) (-1.8247279e-05, 0.00031872389) (-1.8465232e-05, 0.0003183977) (-1.8698928e-05, 0.00031808259) (-1.8947803e-05, 0.00031777934) (-1.9211259e-05, 0.00031748866) (-1.948866e-05, 0.00031721126) (-1.9779339e-05, 0.0003169478) (-2.0082595e-05, 0.00031669893) (-2.0397697e-05, 0.00031646523) (-2.0723887e-05, 0.00031624728) (-2.1060378e-05, 0.00031604559) (-2.140636e-05, 0.00031586066) (-2.1760999e-05, 0.00031569293) (-2.2123441e-05, 0.0003155428) (-2.2492814e-05, 0.00031541064) (-2.2868226e-05, 0.00031529676)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, closed, covered)
  pocket_cp = polyline(z=0, xy: (0.000164, 0.000186) (-0.000164, 0.000186) (-0.00016517621, 0.00018605778) (-0.00016634108, 0.00018623058) (-0.00016748342, 0.00018651672) (-0.0001685922, 0.00018691345) (-0.00016965676, 0.00018741695) (-0.00017066684, 0.00018802236) (-0.00017161272, 0.00018872387) (-0.00017248528, 0.00018951472) (-0.00017327613, 0.00019038728) (-0.00017397764, 0.00019133316) (-0.00017458305, 0.00019234324) (-0.00017508655, 0.0001934078) (-0.00017548328, 0.00019451658) (-0.00017576942, 0.00019565892) (-0.00017594222, 0.00019682379) (-0.000176, 0.000198) (-0.000176, 0.000375) (-0.00017594222, 0.00037617621) (-0.00017576942, 0.00037734108) (-0.00017548328, 0.00037848342) (-0.00017508655, 0.0003795922) (-0.00017458305, 0.00038065676) (-0.00017397764, 0.00038166684) (-0.00017327613, 0.00038261272) (-0.00017248528, 0.00038348528) (-0.00017161272, 0.00038427613) (-0.00017066684, 0.00038497764) (-0.00016965676, 0.00038558305) (-0.0001685922, 0.00038608655) (-0.00016748342, 0.00038648328) (-0.00016634108, 0.00038676942) (-0.00016517621, 0.00038694222) (-0.000164, 0.000387) (0.000164, 0.000387) (0.00016517621, 0.00038694222) (0.00016634108, 0.00038676942) (0.00016748342, 0.00038648328) (0.0001685922, 0.00038608655) (0.00016965676, 0.00038558305) (0.00017066684, 0.00038497764) (0.00017161272, 0.00038427613) (0.00017248528, 0.00038348528) (0.00017327613, 0.00038261272) (0.00017397764, 0.00038166684) (0.00017458305, 0.00038065676) (0.00017508655, 0.0003795922) (0.00017548328, 0.00037848342) (0.00017576942, 0.00037734108) (0.00017594222, 0.00037617621) (0.000176, 0.000375) (0.000176, 0.000198) (0.00017594222, 0.00019682379) (0.00017576942, 0.00019565892) (0.00017548328, 0.00019451658) (0.00017508655, 0.0001934078) (0.00017458305, 0.00019234324) (0.00017397764, 0.00019133316) (0.00017327613, 0.00019038728) (0.00017248528, 0.00018951472) (0.00017161272, 0.00018872387) (0.00017066684, 0.00018802236) (0.00016965676, 0.00018741695) (0.0001685922, 0.00018691345) (0.00016748342, 0.00018651672) (0.00016634108, 0.00018623058) (0.00016517621, 0.00018605778) (0.000164, 0.000186), closed, covered)
  tap_trace_jf [copper] = polyline(z=0, xy: (-8e-06, 0.001465) (-8e-06, 0.001765) (8e-06, 0.001765) (8e-06, 0.001623) (0.000132, 0.001623) (0.000132, 0.001607) (8e-06, 0.001607) (8e-06, 0.001465) (-8e-06, 0.001465), closed, covered)
  tap_cut_jf = polyline(z=0, xy: (-1.7e-05, 0.001465) (-1.7e-05, 0.001765) (1.7e-05, 0.001765) (1.7e-05, 0.001632) (0.000132, 0.001632) (0.000132, 0.001598) (1.7e-05, 0.001598) (1.7e-05, 0.001465) (-1.7e-05, 0.001465), closed, covered)
  tap_trace_jr [copper] = polyline(z=0, xy: (0.000268, 0.001623) (0.000392, 0.001623) (0.000392, 0.001765) (0.000408, 0.001765) (0.000408, 0.001465) (0.000392, 0.001465) (0.000392, 0.001607) (0.000268, 0.001607) (0.000268, 0.001623), closed, covered)
  tap_cut_jr = polyline(z=0, xy: (0.000268, 0.001632) (0.000383, 0.001632) (0.000383, 0.001765) (0.000417, 0.001765) (0.000417, 0.001465) (0.000383, 0.001465) (0.000383, 0.001598) (0.000268, 0.001598) (0.000268, 0.001632), closed, covered)
  head_a_cj [copper] = polyline(z=0, xy: (0.000164, 0.0015825) (0.00016380397, 0.0015825096) (0.00016360982, 0.0015825384) (0.00016341943, 0.0015825861) (0.00016323463, 0.0015826522) (0.00016305721, 0.0015827362) (0.00016288886, 0.0015828371) (0.00016273121, 0.001582954) (0.00016258579, 0.0015830858) (0.00016245398, 0.0015832312) (0.00016233706, 0.0015833889) (0.00016223616, 0.0015835572) (0.00016215224, 0.0015837346) (0.00016208612, 0.0015839194) (0.00016203843, 0.0015841098) (0.00016200963, 0.001584304) (0.000162, 0.0015845) (0.000162, 0.0016455) (0.00016200963, 0.001645696) (0.00016203843, 0.0016458902) (0.00016208612, 0.0016460806) (0.00016215224, 0.0016462654) (0.00016223616, 0.0016464428) (0.00016233706, 0.0016466111) (0.00016245398, 0.0016467688) (0.00016258579, 0.0016469142) (0.00016273121, 0.001647046) (0.00016288886, 0.0016471629) (0.00016305721, 0.0016472638) (0.00016323463, 0.0016473478) (0.00016341943, 0.0016474139) (0.00016360982, 0.0016474616) (0.00016380397, 0.0016474904) (0.000164, 0.0016475) (0.000185, 0.0016475) (0.00018519603, 0.0016474904) (0.00018539018, 0.0016474616) (0.00018558057, 0.0016474139) (0.00018576537, 0.0016473478) (0.00018594279, 0.0016472638) (0.00018611114, 0.0016471629) (0.00018626879, 0.001647046) (0.00018641421, 0.0016469142) (0.00018654602, 0.0016467688) (0.00018666294, 0.0016466111) (0.00018676384, 0.0016464428) (0.00018684776, 0.0016462654) (0.00018691388, 0.0016460806) (0.00018696157, 0.0016458902) (0.00018699037, 0.001645696) (0.000187, 0.0016455) (0.000187, 0.0015845) (0.00018699037, 0.001584304) (0.00018696157, 0.0015841098) (0.00018691388, 0.0015839194) (0.00018684776, 0.0015837346) (0.00018676384, 0.0015835572) (0.00018666294, 0.0015833889) (0.00018654602, 0.0015832312) (0.00018641421, 0.0015830858) (0.00018626879, 0.001582954) (0.00018611114, 0.0015828371) (0.00018594279, 0.0015827362) (0.00018576537, 0.0015826522) (0.00018558057, 0.0015825861) (0.00018539018, 0.0015825384) (0.00018519603, 0.0015825096) (0.000185, 0.0015825) (0.000164, 0.0015825), closed, covered)
  head_b_cj [copper] = polyline(z=0, xy: (0.000215, 0.0015825) (0.00021480397, 0.0015825096) (0.00021460982, 0.0015825384) (0.00021441943, 0.0015825861) (0.00021423463, 0.0015826522) (0.00021405721, 0.0015827362) (0.00021388886, 0.0015828371) (0.00021373121, 0.001582954) (0.00021358579, 0.0015830858) (0.00021345398, 0.0015832312) (0.00021333706, 0.0015833889) (0.00021323616, 0.0015835572) (0.00021315224, 0.0015837346) (0.00021308612, 0.0015839194) (0.00021303843, 0.0015841098) (0.00021300963, 0.001584304) (0.000213, 0.0015845) (0.000213, 0.0016455) (0.00021300963, 0.001645696) (0.00021303843, 0.0016458902) (0.00021308612, 0.0016460806) (0.00021315224, 0.0016462654) (0.00021323616, 0.0016464428) (0.00021333706, 0.0016466111) (0.00021345398, 0.0016467688) (0.00021358579, 0.0016469142) (0.00021373121, 0.001647046) (0.00021388886, 0.0016471629) (0.00021405721, 0.0016472638) (0.00021423463, 0.0016473478) (0.00021441943, 0.0016474139) (0.00021460982, 0.0016474616) (0.00021480397, 0.0016474904) (0.000215, 0.0016475) (0.000236, 0.0016475) (0.00023619603, 0.0016474904) (0.00023639018, 0.0016474616) (0.00023658057, 0.0016474139) (0.00023676537, 0.0016473478) (0.00023694279, 0.0016472638) (0.00023711114, 0.0016471629) (0.00023726879, 0.001647046) (0.00023741421, 0.0016469142) (0.00023754602, 0.0016467688) (0.00023766294, 0.0016466111) (0.00023776384, 0.0016464428) (0.00023784776, 0.0016462654) (0.00023791388, 0.0016460806) (0.00023796157, 0.0016458902) (0.00023799037, 0.001645696) (0.000238, 0.0016455) (0.000238, 0.0015845) (0.00023799037, 0.001584304) (0.00023796157, 0.0015841098) (0.00023791388, 0.0015839194) (0.00023784776, 0.0015837346) (0.00023776384, 0.0015835572) (0.00023766294, 0.0015833889) (0.00023754602, 0.0015832312) (0.00023741421, 0.0015830858) (0.00023726879, 0.001582954) (0.00023711114, 0.0015828371) (0.00023694279, 0.0015827362) (0.00023676537, 0.0015826522) (0.00023658057, 0.0015825861) (0.00023639018, 0.0015825384) (0.00023619603, 0.0015825096) (0.000236, 0.0015825) (0.000215, 0.0015825), closed, covered)
  pocket_cj = polyline(z=0, xy: (0.000148, 0.0015665) (0.00014780397, 0.0015665096) (0.00014760982, 0.0015665384) (0.00014741943, 0.0015665861) (0.00014723463, 0.0015666522) (0.00014705721, 0.0015667362) (0.00014688886, 0.0015668371) (0.00014673121, 0.001566954) (0.00014658579, 0.0015670858) (0.00014645398, 0.0015672312) (0.00014633706, 0.0015673889) (0.00014623616, 0.0015675572) (0.00014615224, 0.0015677346) (0.00014608612, 0.0015679194) (0.00014603843, 0.0015681098) (0.00014600963, 0.001568304) (0.000146, 0.0015685) (0.000146, 0.0016615) (0.00014600963, 0.001661696) (0.00014603843, 0.0016618902) (0.00014608612, 0.0016620806) (0.00014615224, 0.0016622654) (0.00014623616, 0.0016624428) (0.00014633706, 0.0016626111) (0.00014645398, 0.0016627688) (0.00014658579, 0.0016629142) (0.00014673121, 0.001663046) (0.00014688886, 0.0016631629) (0.00014705721, 0.0016632638) (0.00014723463, 0.0016633478) (0.00014741943, 0.0016634139) (0.00014760982, 0.0016634616) (0.00014780397, 0.0016634904) (0.000148, 0.0016635) (0.000252, 0.0016635) (0.00025219603, 0.0016634904) (0.00025239018, 0.0016634616) (0.00025258057, 0.0016634139) (0.00025276537, 0.0016633478) (0.00025294279, 0.0016632638) (0.00025311114, 0.0016631629) (0.00025326879, 0.001663046) (0.00025341421, 0.0016629142) (0.00025354602, 0.0016627688) (0.00025366294, 0.0016626111) (0.00025376384, 0.0016624428) (0.00025384776, 0.0016622654) (0.00025391388, 0.0016620806) (0.00025396157, 0.0016618902) (0.00025399037, 0.001661696) (0.000254, 0.0016615) (0.000254, 0.0015685) (0.00025399037, 0.001568304) (0.00025396157, 0.0015681098) (0.00025391388, 0.0015679194) (0.00025384776, 0.0015677346) (0.00025376384, 0.0015675572) (0.00025366294, 0.0015673889) (0.00025354602, 0.0015672312) (0.00025341421, 0.0015670858) (0.00025326879, 0.001566954) (0.00025311114, 0.0015668371) (0.00025294279, 0.0015667362) (0.00025276537, 0.0015666522) (0.00025258057, 0.0015665861) (0.00025239018, 0.0015665384) (0.00025219603, 0.0015665096) (0.000252, 0.0015665) (0.000148, 0.0015665), closed, covered)
  open_to_ground_readout_open = rectangle(corner=(0.000383, 0.002915, 0), x_size=3.4e-05, y_size=6e-06)
  endcap_filter_tail_end = rectangle(corner=(-0.0008146, 0.0012909213, 0), x_size=2.92e-05, y_size=9.6e-06)
  endcap_res_tail_end = rectangle(corner=(0.0007854, 0.0029225638, 0), x_size=2.92e-05, y_size=9.6e-06)
  ground_main_plane [copper] = rectangle(corner=(-0.0022485, -0.0003765, 0), x_size=0.004497, y_size=0.0034990638)
  main [silicon_eps11p5] = box(corner=(-0.0022485, -0.0003765, -0.0005), size=(0.004497, 0.0034990638, 0.0005))
  ground_main_plane.subtract(tap_cut_jr, lead_b_sub_cp, cut_feed_mid, cut_res_tail, cut_stub_f, pocket_cj, lead_a_sub_cj, tap_cut_jf, cut_feed_out, pocket_cp, lead_b_sub_cin, cut_stub_p, cut_filter_tail, endcap_filter_tail_end, pocket_LPPout, pocket_LPPin, open_to_ground_readout_open, lead_a_sub_cp, lead_b_sub_cj, lead_a_sub_cin, tap_cut_n0, pocket_cin, cut_stub_r, cut_feed_jf, cut_res_open_run, endcap_res_tail_end, cut_feed_in)
boundaries and excitations:
  ThinCond1: ThinConductor Objects=[lead_a_cin, lead_b_cin, lead_a_cp, lead_b_cp, trace_feed_in, trace_feed_mid, trace_feed_out, trace_stub_p, lead_a_cj, lead_b_cj, trace_stub_f, trace_stub_r, trace_feed_jf, trace_res_open_run, trace_filter_tail, trace_res_tail, launch_pad_LPPin, launch_pad_LPPout, plate_cin, frame_cin, tap_trace_n0, plate_cp, frame_cp, tap_trace_jf, tap_trace_jr, head_a_cj, head_b_cj, ground_main_plane] Material=pec Thickness=200nm
  frame_cin: SignalNet Objects=[lead_a_cin, trace_feed_in, launch_pad_LPPin, frame_cin]
  frame_cp: SignalNet Objects=[lead_b_cin, lead_a_cp, trace_feed_mid, trace_feed_out, trace_stub_p, launch_pad_LPPout, plate_cin, tap_trace_n0, frame_cp]
  head_a_cj: SignalNet Objects=[lead_b_cp, lead_a_cj, trace_stub_f, trace_feed_jf, trace_filter_tail, plate_cp, tap_trace_jf, head_a_cj]
  head_b_cj: SignalNet Objects=[lead_b_cj, trace_stub_r, trace_res_open_run, trace_res_tail, tap_trace_jr, head_b_cj]
  g_wb: SignalNet Objects=[g_wb, g_wb_1..g_wb_29, ground_main_plane]
setups:
  Setup: Matrix AdaptiveFreq=6.5GHz Cap{MaxPass=8 MinPass=2 MinConvPass=2 PerError=0.3 PerRefine=30 AutoIncreaseSolutionOrder SolutionOrder=Normal Solver_Type=Iterative}
source amplitudes:
  frame_cin: Cap 1V 0deg
  frame_cp, g_wb, head_a_cj, head_b_cj: Cap 0V 0deg

design Q400g36_1650_q3d (Q3D Extractor, model units mm)
options: SParamCalcMethod=EqTransLine Calculate_Lossy_Dielectrics
geometry:
  lead_a_cin_path = polyline((-0.000744499, 0, 0) (-0.0007925, 0, 0))
  lead_a_cin [copper] = polyline((-0.000744499, -8e-06, 0) (-0.000744499, 8e-06, 0))
  lead_a_cin.sweep_along_path(lead_a_cin_path)
  lead_a_sub_cin_path = polyline((-0.000744499, 0, 0) (-0.0007925, 0, 0))
  lead_a_sub_cin = polyline((-0.000744499, -1.7e-05, 0) (-0.000744499, 1.7e-05, 0))
  lead_a_sub_cin.sweep_along_path(lead_a_sub_cin_path)
  lead_b_cin_path = polyline((-0.000639501, 0, 0) (-0.0005275, 0, 0))
  lead_b_cin [copper] = polyline((-0.000639501, 8e-06, 0) (-0.000639501, -8e-06, 0))
  lead_b_cin.sweep_along_path(lead_b_cin_path)
  lead_b_sub_cin_path = polyline((-0.000639501, 0, 0) (-0.0005275, 0, 0))
  lead_b_sub_cin = polyline((-0.000639501, 1.7e-05, 0) (-0.000639501, -1.7e-05, 0))
  lead_b_sub_cin.sweep_along_path(lead_b_sub_cin_path)
  lead_a_cp_path = polyline((0, 0.000198001, 0) (0, 0.00015, 0))
  lead_a_cp [copper] = polyline((8e-06, 0.000198001, 0) (-8e-06, 0.000198001, 0))
  lead_a_cp.sweep_along_path(lead_a_cp_path)
  lead_a_sub_cp_path = polyline((0, 0.000198001, 0) (0, 0.00015, 0))
  lead_a_sub_cp = polyline((1.7e-05, 0.000198001, 0) (-1.7e-05, 0.000198001, 0))
  lead_a_sub_cp.sweep_along_path(lead_a_sub_cp_path)
  lead_b_cp_path = polyline((0, 0.000302999, 0) (0, 0.000415, 0))
  lead_b_cp [copper] = polyline((-8e-06, 0.000302999, 0) (8e-06, 0.000302999, 0))
  lead_b_cp.sweep_along_path(lead_b_cp_path)
  lead_b_sub_cp_path = polyline((0, 0.000302999, 0) (0, 0.000415, 0))
  lead_b_sub_cp = polyline((-1.7e-05, 0.000302999, 0) (1.7e-05, 0.000302999, 0))
  lead_b_sub_cp.sweep_along_path(lead_b_sub_cp_path)
  trace_feed_in_path = polyline((-0.00162, 0, 0) (-0.0007925, 0, 0))
  trace_feed_in [copper] = polyline((-0.00162, 8e-06, 0) (-0.00162, -8e-06, 0))
  trace_feed_in.sweep_along_path(trace_feed_in_path)
  cut_feed_in_path = polyline((-0.00162, 0, 0) (-0.0007925, 0, 0))
  cut_feed_in = polyline((-0.00162, 1.7e-05, 0) (-0.00162, -1.7e-05, 0))
  cut_feed_in.sweep_along_path(cut_feed_in_path)
  trace_feed_mid_path = polyline((-0.0005275, 0, 0) (-0.00015, 0, 0))
  trace_feed_mid [copper] = polyline((-0.0005275, 8e-06, 0) (-0.0005275, -8e-06, 0))
  trace_feed_mid.sweep_along_path(trace_feed_mid_path)
  cut_feed_mid_path = polyline((-0.0005275, 0, 0) (-0.00015, 0, 0))
  cut_feed_mid = polyline((-0.0005275, 1.7e-05, 0) (-0.0005275, -1.7e-05, 0))
  cut_feed_mid.sweep_along_path(cut_feed_mid_path)
  trace_feed_out_path = polyline((0.00015, 0, 0) (0.00162, 0, 0))
  trace_feed_out [copper] = polyline((0.00015, 8e-06, 0) (0.00015, -8e-06, 0))
  trace_feed_out.sweep_along_path(trace_feed_out_path)
  cut_feed_out_path = polyline((0.00015, 0, 0) (0.00162, 0, 0))
  cut_feed_out = polyline((0.00015, 1.7e-05, 0) (0.00015, -1.7e-05, 0))
  cut_feed_out.sweep_along_path(cut_feed_out_path)
  trace_stub_p_path = polyline((0, 0.0001, 0) (0, 0.00015, 0))
  trace_stub_p [copper] = polyline((-8e-06, 0.0001, 0) (8e-06, 0.0001, 0))
  trace_stub_p.sweep_along_path(trace_stub_p_path)
  cut_stub_p_path = polyline((0, 0.0001, 0) (0, 0.00015, 0))
  cut_stub_p = polyline((-1.7e-05, 0.0001, 0) (1.7e-05, 0.0001, 0))
  cut_stub_p.sweep_along_path(cut_stub_p_path)
  lead_a_cj_path = polyline((0.000157001, 0.001615, 0) (0.000147, 0.001615, 0))
  lead_a_cj [copper] = polyline((0.000157001, 0.001607, 0) (0.000157001, 0.001623, 0))
  lead_a_cj.sweep_along_path(lead_a_cj_path)
  lead_a_sub_cj_path = polyline((0.000157001, 0.001615, 0) (0.000147, 0.001615, 0))
  lead_a_sub_cj = polyline((0.000157001, 0.001598, 0) (0.000157001, 0.001632, 0))
  lead_a_sub_cj.sweep_along_path(lead_a_sub_cj_path)
  lead_b_cj_path = polyline((0.000242999, 0.001615, 0) (0.000253, 0.001615, 0))
  lead_b_cj [copper] = polyline((0.000242999, 0.001623, 0) (0.000242999, 0.001607, 0))
  lead_b_cj.sweep_along_path(lead_b_cj_path)
  lead_b_sub_cj_path = polyline((0.000242999, 0.001615, 0) (0.000253, 0.001615, 0))
  lead_b_sub_cj = polyline((0.000242999, 0.001632, 0) (0.000242999, 0.001598, 0))
  lead_b_sub_cj.sweep_along_path(lead_b_sub_cj_path)
  trace_stub_f_path = polyline((0.000127, 0.001615, 0) (0.000147, 0.001615, 0))
  trace_stub_f [copper] = polyline((0.000127, 0.001623, 0) (0.000127, 0.001607, 0))
  trace_stub_f.sweep_along_path(trace_stub_f_path)
  cut_stub_f_path = polyline((0.000127, 0.001615, 0) (0.000147, 0.001615, 0))
  cut_stub_f = polyline((0.000127, 0.001632, 0) (0.000127, 0.001598, 0))
  cut_stub_f.sweep_along_path(cut_stub_f_path)
  trace_stub_r_path = polyline((0.000253, 0.001615, 0) (0.000273, 0.001615, 0))
  trace_stub_r [copper] = polyline((0.000253, 0.001623, 0) (0.000253, 0.001607, 0))
  trace_stub_r.sweep_along_path(trace_stub_r_path)
  cut_stub_r_path = polyline((0.000253, 0.001615, 0) (0.000273, 0.001615, 0))
  cut_stub_r = polyline((0.000253, 0.001632, 0) (0.000253, 0.001598, 0))
  cut_stub_r.sweep_along_path(cut_stub_r_path)
  trace_feed_jf_path = polyline((0, 0.000415, 0) (0, 0.001465, 0))
  trace_feed_jf [copper] = polyline((-8e-06, 0.000415, 0) (8e-06, 0.000415, 0))
  trace_feed_jf.sweep_along_path(trace_feed_jf_path)
  cut_feed_jf_path = polyline((0, 0.000415, 0) (0, 0.001465, 0))
  cut_feed_jf = polyline((-1.7e-05, 0.000415, 0) (1.7e-05, 0.000415, 0))
  cut_feed_jf.sweep_along_path(cut_feed_jf_path)
  trace_res_open_run_path = polyline((0.0004, 0.001765, 0) (0.0004, 0.002915, 0))
  trace_res_open_run [copper] = polyline((0.000392, 0.001765, 0) (0.000408, 0.001765, 0))
  trace_res_open_run.sweep_along_path(trace_res_open_run_path)
  cut_res_open_run_path = polyline((0.0004, 0.001765, 0) (0.0004, 0.002915, 0))
  cut_res_open_run = polyline((0.000383, 0.001765, 0) (0.000417, 0.001765, 0))
  cut_res_open_run.sweep_along_path(cut_res_open_run_path)
  trace_filter_tail_path = polyline(z=0, xy: (0, 0.001765) (0, 0.002165) (-0.0004, 0.002165) (-0.0004, 0.00065) (-0.0008, 0.00065) (-0.0008, 0.0012909213))
  trace_filter_tail_path.fillet(Vertices=trace_filter_tail_path.vertex(2 of 6, 3 of 6, 4 of 6, 5 of 6) Radius=9.9e-05 Setback=0mm)
  trace_filter_tail [copper] = polyline((-8e-06, 0.001765, 0) (8e-06, 0.001765, 0))
  trace_filter_tail.sweep_along_path(trace_filter_tail_path)
  cut_filter_tail_path = polyline(z=0, xy: (0, 0.001765) (0, 0.002165) (-0.0004, 0.002165) (-0.0004, 0.00065) (-0.0008, 0.00065) (-0.0008, 0.0012909213))
  cut_filter_tail_path.fillet(Vertices=cut_filter_tail_path.vertex(2 of 6, 3 of 6, 4 of 6, 5 of 6) Radius=9.9e-05 Setback=0mm)
  cut_filter_tail = polyline((-1.7e-05, 0.001765, 0) (1.7e-05, 0.001765, 0))
  cut_filter_tail.sweep_along_path(cut_filter_tail_path)
  trace_res_tail_path = polyline(z=0, xy: (0.0004, 0.001465) (0.0004, 0.00065) (0.0008, 0.00065) (0.0008, 0.0029225638))
  trace_res_tail_path.fillet(Vertices=trace_res_tail_path.vertex(2 of 4, 3 of 4) Radius=9.9e-05 Setback=0mm)
  trace_res_tail [copper] = polyline((0.000408, 0.001465, 0) (0.000392, 0.001465, 0))
  trace_res_tail.sweep_along_path(trace_res_tail_path)
  cut_res_tail_path = polyline(z=0, xy: (0.0004, 0.001465) (0.0004, 0.00065) (0.0008, 0.00065) (0.0008, 0.0029225638))
  cut_res_tail_path.fillet(Vertices=cut_res_tail_path.vertex(2 of 4, 3 of 4) Radius=9.9e-05 Setback=0mm)
  cut_res_tail = polyline((0.000417, 0.001465, 0) (0.000383, 0.001465, 0))
  cut_res_tail.sweep_along_path(cut_res_tail_path)
  g_wb [pec] = bondwire(WireType=LOW WireDiameter=0.015mm NumSides=6 XPadPos=-0.0013441667 YPadPos=-3.4e-05 ZPadPos=0 XDir=0 YDir=1 ZDir=0 Distance=6.8e-05 h1=6.8e-05 h2=0mm alpha=80deg beta=80deg WhichAxis=Z)
  g_wb_1 [pec] = bondwire(WireType=LOW WireDiameter=0.015mm NumSides=6 XPadPos=-0.0010683333 YPadPos=-3.4e-05 ZPadPos=0 XDir=0 YDir=1 ZDir=0 Distance=6.8e-05 h1=6.8e-05 h2=0mm alpha=80deg beta=80deg WhichAxis=Z)
  g_wb_2 [pec] = bondwire(WireType=LOW WireDiameter=0.015mm NumSides=6 XPadPos=-0.00033875 YPadPos=-3.4e-05 ZPadPos=0 XDir=0 YDir=1 ZDir=0 Distance=6.8e-05 h1=6.8e-05 h2=0mm alpha=80deg beta=80deg WhichAxis=Z)
  g_wb_3 [pec] = bondwire(WireType=LOW WireDiameter=0.015mm NumSides=6 XPadPos=0.000444 YPadPos=-3.4e-05 ZPadPos=0 XDir=0 YDir=1 ZDir=0 Distance=6.8e-05 h1=6.8e-05 h2=0mm alpha=80deg beta=80deg WhichAxis=Z)
  g_wb_4 [pec] = bondwire(WireType=LOW WireDiameter=0.015mm NumSides=6 XPadPos=0.000738 YPadPos=-3.4e-05 ZPadPos=0 XDir=0 YDir=1 ZDir=0 Distance=6.8e-05 h1=6.8e-05 h2=0mm alpha=80deg beta=80deg WhichAxis=Z)
  g_wb_5 [pec] = bondwire(WireType=LOW WireDiameter=0.015mm NumSides=6 XPadPos=0.001032 YPadPos=-3.4e-05 ZPadPos=0 XDir=0 YDir=1 ZDir=0 Distance=6.8e-05 h1=6.8e-05 h2=0mm alpha=80deg beta=80deg WhichAxis=Z)
  g_wb_6 [pec] = bondwire(WireType=LOW WireDiameter=0.015mm NumSides=6 XPadPos=0.001326 YPadPos=-3.4e-05 ZPadPos=0 XDir=0 YDir=1 ZDir=0 Distance=6.8e-05 h1=6.8e-05 h2=0mm alpha=80deg beta=80deg WhichAxis=Z)
  g_wb_7 [pec] = bondwire(WireType=LOW WireDiameter=0.015mm NumSides=6 XPadPos=3.4e-05 YPadPos=0.0006775 ZPadPos=0 XDir=-1 YDir=0 ZDir=0 Distance=6.8e-05 h1=6.8e-05 h2=0mm alpha=80deg beta=80deg WhichAxis=Z)
  g_wb_8 [pec] = bondwire(WireType=LOW WireDiameter=0.015mm NumSides=6 XPadPos=3.4e-05 YPadPos=0.00094 ZPadPos=0 XDir=-1 YDir=0 ZDir=0 Distance=6.8e-05 h1=6.8e-05 h2=0mm alpha=80deg beta=80deg WhichAxis=Z)
  g_wb_9 [pec] = bondwire(WireType=LOW WireDiameter=0.015mm NumSides=6 XPadPos=3.4e-05 YPadPos=0.0012025 ZPadPos=0 XDir=-1 YDir=0 ZDir=0 Distance=6.8e-05 h1=6.8e-05 h2=0mm alpha=80deg beta=80deg WhichAxis=Z)
  g_wb_10 [pec] = bondwire(WireType=LOW WireDiameter=0.015mm NumSides=6 XPadPos=0.000434 YPadPos=0.0020525 ZPadPos=0 XDir=-1 YDir=0 ZDir=0 Distance=6.8e-05 h1=6.8e-05 h2=0mm alpha=80deg beta=80deg WhichAxis=Z)
  g_wb_11 [pec] = bondwire(WireType=LOW WireDiameter=0.015mm NumSides=6 XPadPos=0.000434 YPadPos=0.00234 ZPadPos=0 XDir=-1 YDir=0 ZDir=0 Distance=6.8e-05 h1=6.8e-05 h2=0mm alpha=80deg beta=80deg WhichAxis=Z)
  g_wb_12 [pec] = bondwire(WireType=LOW WireDiameter=0.015mm NumSides=6 XPadPos=0.000434 YPadPos=0.0026275 ZPadPos=0 XDir=-1 YDir=0 ZDir=0 Distance=6.8e-05 h1=6.8e-05 h2=0mm alpha=80deg beta=80deg WhichAxis=Z)
  g_wb_13 [pec] = bondwire(WireType=LOW WireDiameter=0.015mm NumSides=6 XPadPos=3.4e-05 YPadPos=0.001965 ZPadPos=0 XDir=-1 YDir=0 ZDir=0 Distance=6.8e-05 h1=6.8e-05 h2=0mm alpha=80deg beta=80deg WhichAxis=Z)
  g_wb_14 [pec] = bondwire(WireType=LOW WireDiameter=0.015mm NumSides=6 XPadPos=-0.0002 YPadPos=0.002199 ZPadPos=0 XDir=0 YDir=-1 ZDir=0 Distance=6.8e-05 h1=6.8e-05 h2=0mm alpha=80deg beta=80deg WhichAxis=Z)
  g_wb_15 [pec] = bondwire(WireType=LOW WireDiameter=0.015mm NumSides=6 XPadPos=-0.000434 YPadPos=0.001862 ZPadPos=0 XDir=1 YDir=0 ZDir=0 Distance=6.8e-05 h1=6.8e-05 h2=0mm alpha=80deg beta=80deg WhichAxis=Z)
  g_wb_16 [pec] = bondwire(WireType=LOW WireDiameter=0.015mm NumSides=6 XPadPos=-0.000434 YPadPos=0.001559 ZPadPos=0 XDir=1 YDir=0 ZDir=0 Distance=6.8e-05 h1=6.8e-05 h2=0mm alpha=80deg beta=80deg WhichAxis=Z)
  g_wb_17 [pec] = bondwire(WireType=LOW WireDiameter=0.015mm NumSides=6 XPadPos=-0.000434 YPadPos=0.001256 ZPadPos=0 XDir=1 YDir=0 ZDir=0 Distance=6.8e-05 h1=6.8e-05 h2=0mm alpha=80deg beta=80deg WhichAxis=Z)
  g_wb_18 [pec] = bondwire(WireType=LOW WireDiameter=0.015mm NumSides=6 XPadPos=-0.000434 YPadPos=0.000953 ZPadPos=0 XDir=1 YDir=0 ZDir=0 Distance=6.8e-05 h1=6.8e-05 h2=0mm alpha=80deg beta=80deg WhichAxis=Z)
  g_wb_19 [pec] = bondwire(WireType=LOW WireDiameter=0.015mm NumSides=6 XPadPos=-0.0006 YPadPos=0.000684 ZPadPos=0 XDir=0 YDir=-1 ZDir=0 Distance=6.8e-05 h1=6.8e-05 h2=0mm alpha=80deg beta=80deg WhichAxis=Z)
  g_wb_20 [pec] = bondwire(WireType=LOW WireDiameter=0.015mm NumSides=6 XPadPos=-0.000766 YPadPos=0.00097046066 ZPadPos=0 XDir=-1 YDir=0 ZDir=0 Distance=6.8e-05 h1=6.8e-05 h2=0mm alpha=80deg beta=80deg WhichAxis=Z)
  g_wb_21 [pec] = bondwire(WireType=LOW WireDiameter=0.015mm NumSides=6 XPadPos=0.000366 YPadPos=0.0011933333 ZPadPos=0 XDir=1 YDir=0 ZDir=0 Distance=6.8e-05 h1=6.8e-05 h2=0mm alpha=80deg beta=80deg WhichAxis=Z)
  g_wb_22 [pec] = bondwire(WireType=LOW WireDiameter=0.015mm NumSides=6 XPadPos=0.000366 YPadPos=0.00092166667 ZPadPos=0 XDir=1 YDir=0 ZDir=0 Distance=6.8e-05 h1=6.8e-05 h2=0mm alpha=80deg beta=80deg WhichAxis=Z)
  g_wb_23 [pec] = bondwire(WireType=LOW WireDiameter=0.015mm NumSides=6 XPadPos=0.0006 YPadPos=0.000616 ZPadPos=0 XDir=0 YDir=1 ZDir=0 Distance=6.8e-05 h1=6.8e-05 h2=0mm alpha=80deg beta=80deg WhichAxis=Z)
  g_wb_24 [pec] = bondwire(WireType=LOW WireDiameter=0.015mm NumSides=6 XPadPos=0.000834 YPadPos=0.00097465197 ZPadPos=0 XDir=-1 YDir=0 ZDir=0 Distance=6.8e-05 h1=6.8e-05 h2=0mm alpha=80deg beta=80deg WhichAxis=Z)
  g_wb_25 [pec] = bondwire(WireType=LOW WireDiameter=0.015mm NumSides=6 XPadPos=0.000834 YPadPos=0.0012993039 ZPadPos=0 XDir=-1 YDir=0 ZDir=0 Distance=6.8e-05 h1=6.8e-05 h2=0mm alpha=80deg beta=80deg WhichAxis=Z)
  g_wb_26 [pec] = bondwire(WireType=LOW WireDiameter=0.015mm NumSides=6 XPadPos=0.000834 YPadPos=0.0016239559 ZPadPos=0 XDir=-1 YDir=0 ZDir=0 Distance=6.8e-05 h1=6.8e-05 h2=0mm alpha=80deg beta=80deg WhichAxis=Z)
  g_wb_27 [pec] = bondwire(WireType=LOW WireDiameter=0.015mm NumSides=6 XPadPos=0.000834 YPadPos=0.0019486079 ZPadPos=0 XDir=-1 YDir=0 ZDir=0 Distance=6.8e-05 h1=6.8e-05 h2=0mm alpha=80deg beta=80deg WhichAxis=Z)
  g_wb_28 [pec] = bondwire(WireType=LOW WireDiameter=0.015mm NumSides=6 XPadPos=0.000834 YPadPos=0.0022732598 ZPadPos=0 XDir=-1 YDir=0 ZDir=0 Distance=6.8e-05 h1=6.8e-05 h2=0mm alpha=80deg beta=80deg WhichAxis=Z)
  g_wb_29 [pec] = bondwire(WireType=LOW WireDiameter=0.015mm NumSides=6 XPadPos=0.000834 YPadPos=0.0025979118 ZPadPos=0 XDir=-1 YDir=0 ZDir=0 Distance=6.8e-05 h1=6.8e-05 h2=0mm alpha=80deg beta=80deg WhichAxis=Z)
  launch_pad_LPPin [copper] = polyline(z=0, xy: (-0.00165, 8e-06) (-0.001772, 0.0001) (-0.001972, 0.0001) (-0.001972, -0.0001) (-0.001772, -0.0001) (-0.00165, -8e-06) (-0.00162, -8e-06) (-0.00162, 8e-06) (-0.00165, 8e-06), closed, covered)
  pocket_LPPin = polyline(z=0, xy: (-0.00165, 1.7e-05) (-0.001772, 0.0001765) (-0.0020485, 0.0001765) (-0.0020485, -0.0001765) (-0.001772, -0.0001765) (-0.00165, -1.7e-05) (-0.00162, -1.7e-05) (-0.00162, 1.7e-05) (-0.00165, 1.7e-05), closed, covered)
  launch_pad_LPPout [copper] = polyline(z=0, xy: (0.00165, -8e-06) (0.001772, -0.0001) (0.001972, -0.0001) (0.001972, 0.0001) (0.001772, 0.0001) (0.00165, 8e-06) (0.00162, 8e-06) (0.00162, -8e-06) (0.00165, -8e-06), closed, covered)
  pocket_LPPout = polyline(z=0, xy: (0.00165, -1.7e-05) (0.001772, -0.0001765) (0.0020485, -0.0001765) (0.0020485, 0.0001765) (0.001772, 0.0001765) (0.00165, 1.7e-05) (0.00162, 1.7e-05) (0.00162, -1.7e-05) (0.00165, -1.7e-05), closed, covered)
  plate_cin [copper] = polyline(z=0, xy: (-0.0006725, -9.25e-05) (-0.00067328414, -9.2461478e-05) (-0.00067406072, -9.2346282e-05) (-0.00067482228, -9.2155523e-05) (-0.00067556147, -9.1891036e-05) (-0.00067627117, -9.155537e-05) (-0.00067694456, -9.1151757e-05) (-0.00067757515, -9.0684084e-05) (-0.00067815685, -9.0156854e-05) (-0.00067868408, -8.9575146e-05) (-0.00067915176, -8.8944562e-05) (-0.00067955537, -8.8271174e-05) (-0.00067989104, -8.7561467e-05) (-0.00068015552, -8.6822277e-05) (-0.00068034628, -8.6060723e-05) (-0.00068046148, -8.5284137e-05) (-0.0006805, -8.45e-05) (-0.0006805, 8.45e-05) (-0.00068046148, 8.5284137e-05) (-0.00068034628, 8.6060723e-05) (-0.00068015552, 8.6822277e-05) (-0.00067989104, 8.7561467e-05) (-0.00067955537, 8.8271174e-05) (-0.00067915176, 8.8944562e-05) (-0.00067868408, 8.9575146e-05) (-0.00067815685, 9.0156854e-05) (-0.00067757515, 9.0684084e-05) (-0.00067694456, 9.1151757e-05) (-0.00067627117, 9.155537e-05) (-0.00067556147, 9.1891036e-05) (-0.00067482228, 9.2155523e-05) (-0.00067406072, 9.2346282e-05) (-0.00067328414, 9.2461478e-05) (-0.0006725, 9.25e-05) (-0.0006475, 9.25e-05) (-0.00064671586, 9.2461478e-05) (-0.00064593928, 9.2346282e-05) (-0.00064517772, 9.2155523e-05) (-0.00064443853, 9.1891036e-05) (-0.00064372883, 9.155537e-05) (-0.00064305544, 9.1151757e-05) (-0.00064242485, 9.0684084e-05) (-0.00064184315, 9.0156854e-05) (-0.00064131592, 8.9575146e-05) (-0.00064084824, 8.8944562e-05) (-0.00064044463, 8.8271174e-05) (-0.00064010896, 8.7561467e-05) (-0.00063984448, 8.6822277e-05) (-0.00063965372, 8.6060723e-05) (-0.00063953852, 8.5284137e-05) (-0.0006395, 8.45e-05) (-0.0006395, -8.45e-05) (-0.00063953852, -8.5284137e-05) (-0.00063965372, -8.6060723e-05) (-0.00063984448, -8.6822277e-05) (-0.00064010896, -8.7561467e-05) (-0.00064044463, -8.8271174e-05) (-0.00064084824, -8.8944562e-05) (-0.00064131592, -8.9575146e-05) (-0.00064184315, -9.0156854e-05) (-0.00064242485, -9.0684084e-05) (-0.00064305544, -9.1151757e-05) (-0.00064372883, -9.155537e-05) (-0.00064443853, -9.1891036e-05) (-0.00064517772, -9.2155523e-05) (-0.00064593928, -9.2346282e-05) (-0.00064671586, -9.2461478e-05) (-0.0006475, -9.25e-05) (-0.0006725, -9.25e-05), closed, covered)
  frame_cin [copper] = polyline(z=0, xy: (-0.0006925, -9.65e-05) (-0.00069246148, -9.7284137e-05) (-0.00069234628, -9.8060723e-05) (-0.00069215552, -9.8822277e-05) (-0.00069189104, -9.9561467e-05) (-0.00069155537, -0.00010027117) (-0.00069115176, -0.00010094456) (-0.00069068408, -0.00010157515) (-0.00069015685, -0.00010215685) (-0.00068957515, -0.00010268408) (-0.00068894456, -0.00010315176) (-0.00068827117, -0.00010355537) (-0.00068756147, -0.00010389104) (-0.00068682228, -0.00010415552) (-0.00068606072, -0.00010434628) (-0.00068528414, -0.00010446148) (-0.0006845, -0.0001045) (-0.0006355, -0.0001045) (-0.00063471586, -0.00010446148) (-0.00063393928, -0.00010434628) (-0.00063317772, -0.00010415552) (-0.00063243853, -0.00010389104) (-0.00063172883, -0.00010355537) (-0.00063105544, -0.00010315176) (-0.00063042485, -0.00010268408) (-0.00062984315, -0.00010215685) (-0.00062931592, -0.00010157515) (-0.00062884824, -0.00010094456) (-0.00062844463, -0.00010027117) (-0.00062810896, -9.9561467e-05) (-0.00062784448, -9.8822277e-05) (-0.00062765372, -9.8060723e-05) (-0.00062753852, -9.7284137e-05) (-0.0006275, -9.65e-05) (-0.0006275, -2.509818e-05) (-0.00062749518, -2.4901939e-05) (-0.00062747111, -2.4412015e-05) (-0.00062743266, -2.40216e-05) (-0.0006273751, -2.3633541e-05) (-0.00062729856, -2.3248774e-05) (-0.00062720324, -2.2868226e-05) (-0.00062708936, -2.2492814e-05) (-0.0006269572, -2.2123441e-05) (-0.00062680707, -2.1760999e-05) (-0.00062663934, -2.140636e-05) (-0.00062645441, -2.1060378e-05) (-0.00062625272, -2.0723887e-05) (-0.00062603477, -2.0397697e-05) (-0.00062580107, -2.0082595e-05) (-0.0006255522, -1.9779339e-05) (-0.00062528874, -1.948866e-05) (-0.00062501134, -1.9211259e-05) (-0.00062472066, -1.8947803e-05) (-0.0006244174, -1.8698928e-05) (-0.0006241023, -1.8465232e-05) (-0.00062377611, -1.8247279e-05) (-0.00062343962, -1.8045594e-05) (-0.00062309364, -1.7860663e-05) (-0.000622739, -1.7692931e-05) (-0.00062237656, -1.7542802e-05) (-0.00062200719, -1.7410639e-05) (-0.00062163177, -1.7296759e-05) (-0.00062125123, -1.7201436e-05) (-0.00062086646, -1.7124902e-05) (-0.0006204784, -1.7067338e-05) (-0.00062008799, -1.7028886e-05) (-0.00061959806, -1.7004817e-05) (-0.00061940182, -1.7e-05) (-0.00057559818, -1.7e-05) (-0.00057540194, -1.7004817e-05) (-0.00057491201, -1.7028886e-05) (-0.0005745216, -1.7067338e-05) (-0.00057413354, -1.7124902e-05) (-0.00057374877, -1.7201436e-05) (-0.00057336823, -1.7296759e-05) (-0.00057299281, -1.7410639e-05) (-0.00057262344, -1.7542802e-05) (-0.000572261, -1.7692931e-05) (-0.00057190636, -1.7860663e-05) (-0.00057156038, -1.8045594e-05) (-0.00057122389, -1.8247279e-05) (-0.0005708977, -1.8465232e-05) (-0.0005705826, -1.8698928e-05) (-0.00057027934, -1.8947803e-05) (-0.00056998866, -1.9211259e-05) (-0.00056971126, -1.948866e-05) (-0.0005694478, -1.9779339e-05) (-0.00056919893, -2.0082595e-05) (-0.00056896523, -2.0397697e-05) (-0.00056874728, -2.0723887e-05) (-0.00056854559, -2.1060378e-05) (-0.00056836066, -2.140636e-05) (-0.00056819293, -2.1760999e-05) (-0.0005680428, -2.2123441e-05) (-0.00056791064, -2.2492814e-05) (-0.00056779676, -2.2868226e-05) (-0.00056770144, -2.3248774e-05) (-0.0005676249, -2.3633541e-05) (-0.00056756734, -2.40216e-05) (-0.00056752889, -2.4412015e-05) (-0.00056750482, -2.4901939e-05) (-0.0005675, -2.509818e-05) (-0.0005675, -0.00015340182) (-0.00056750482, -0.00015359806) (-0.00056752889, -0.00015408799) (-0.00056756734, -0.0001544784) (-0.0005676249, -0.00015486646) (-0.00056770144, -0.00015525123) (-0.00056779676, -0.00015563177) (-0.00056791064, -0.00015600719) (-0.0005680428, -0.00015637656) (-0.00056819293, -0.000156739) (-0.00056836066, -0.00015709364) (-0.00056854559, -0.00015743962) (-0.00056874728, -0.00015777611) (-0.00056896523, -0.0001581023) (-0.00056919893, -0.00015841741) (-0.0005694478, -0.00015872066) (-0.00056971126, -0.00015901134) (-0.00056998866, -0.00015928874) (-0.00057027934, -0.0001595522) (-0.0005705826, -0.00015980107) (-0.0005708977, -0.00016003477) (-0.00057122389, -0.00016025272) (-0.00057156038, -0.00016045441) (-0.00057190636, -0.00016063934) (-0.000572261, -0.00016080707) (-0.00057262344, -0.0001609572) (-0.00057299281, -0.00016108936) (-0.00057336823, -0.00016120324) (-0.00057374877, -0.00016129856) (-0.00057413354, -0.0001613751) (-0.0005745216, -0.00016143266) (-0.00057491201, -0.00016147111) (-0.00057540194, -0.00016149518) (-0.00057559818, -0.0001615) (-0.00073640182, -0.0001615) (-0.00073659806, -0.00016149518) (-0.00073708798, -0.00016147111) (-0.0007374784, -0.00016143266) (-0.00073786646, -0.0001613751) (-0.00073825123, -0.00016129856) (-0.00073863177, -0.00016120324) (-0.00073900719, -0.00016108936) (-0.00073937656, -0.0001609572) (-0.000739739, -0.00016080707) (-0.00074009364, -0.00016063934) (-0.00074043962, -0.00016045441) (-0.00074077611, -0.00016025272) (-0.0007411023, -0.00016003477) (-0.0007414174, -0.00015980107) (-0.00074172066, -0.0001595522) (-0.00074201134, -0.00015928874) (-0.00074228874, -0.00015901134) (-0.0007425522, -0.00015872066) (-0.00074280107, -0.00015841741) (-0.00074303477, -0.0001581023) (-0.00074325272, -0.00015777611) (-0.00074345441, -0.00015743962) (-0.00074363934, -0.00015709364) (-0.00074380707, -0.000156739) (-0.0007439572, -0.00015637656) (-0.00074408936, -0.00015600719) (-0.00074420324, -0.00015563177) (-0.00074429856, -0.00015525123) (-0.0007443751, -0.00015486646) (-0.00074443266, -0.0001544784) (-0.00074447111, -0.00015408799) (-0.00074449518, -0.00015359806) (-0.0007445, -0.00015340182) (-0.0007445, 0.00015340182) (-0.00074449518, 0.00015359806) (-0.00074447111, 0.00015408799) (-0.00074443266, 0.0001544784) (-0.0007443751, 0.00015486646) (-0.00074429856, 0.00015525123) (-0.00074420324, 0.00015563177) (-0.00074408936, 0.00015600719) (-0.0007439572, 0.00015637656) (-0.00074380707, 0.000156739) (-0.00074363934, 0.00015709364) (-0.00074345441, 0.00015743962) (-0.00074325272, 0.00015777611) (-0.00074303477, 0.0001581023) (-0.00074280107, 0.00015841741) (-0.0007425522, 0.00015872066) (-0.00074228874, 0.00015901134) (-0.00074201134, 0.00015928874) (-0.00074172066, 0.0001595522) (-0.0007414174, 0.00015980107) (-0.0007411023, 0.00016003477) (-0.00074077611, 0.00016025272) (-0.00074043962, 0.00016045441) (-0.00074009364, 0.00016063934) (-0.000739739, 0.00016080707) (-0.00073937656, 0.0001609572) (-0.00073900719, 0.00016108936) (-0.00073863177, 0.00016120324) (-0.00073825123, 0.00016129856) (-0.00073786646, 0.0001613751) (-0.0007374784, 0.00016143266) (-0.00073708798, 0.00016147111) (-0.00073659806, 0.00016149518) (-0.00073640182, 0.0001615) (-0.00057559818, 0.0001615) (-0.00057540194, 0.00016149518) (-0.00057491201, 0.00016147111) (-0.0005745216, 0.00016143266) (-0.00057413354, 0.0001613751) (-0.00057374877, 0.00016129856) (-0.00057336823, 0.00016120324) (-0.00057299281, 0.00016108936) (-0.00057262344, 0.0001609572) (-0.000572261, 0.00016080707) (-0.00057190636, 0.00016063934) (-0.00057156038, 0.00016045441) (-0.00057122389, 0.00016025272) (-0.0005708977, 0.00016003477) (-0.0005705826, 0.00015980107) (-0.00057027934, 0.0001595522) (-0.00056998866, 0.00015928874) (-0.00056971126, 0.00015901134) (-0.0005694478, 0.00015872066) (-0.00056919893, 0.00015841741) (-0.00056896523, 0.0001581023) (-0.00056874728, 0.00015777611) (-0.00056854559, 0.00015743962) (-0.00056836066, 0.00015709364) (-0.00056819293, 0.000156739) (-0.0005680428, 0.00015637656) (-0.00056791064, 0.00015600719) (-0.00056779676, 0.00015563177) (-0.00056770144, 0.00015525123) (-0.0005676249, 0.00015486646) (-0.00056756734, 0.0001544784) (-0.00056752889, 0.00015408799) (-0.00056750482, 0.00015359806) (-0.0005675, 0.00015340182) (-0.0005675, 2.509818e-05) (-0.00056750482, 2.4901939e-05) (-0.00056752889, 2.4412015e-05) (-0.00056756734, 2.40216e-05) (-0.0005676249, 2.3633541e-05) (-0.00056770144, 2.3248774e-05) (-0.00056779676, 2.2868226e-05) (-0.00056791064, 2.2492814e-05) (-0.0005680428, 2.2123441e-05) (-0.00056819293, 2.1760999e-05) (-0.00056836066, 2.140636e-05) (-0.00056854559, 2.1060378e-05) (-0.00056874728, 2.0723887e-05) (-0.00056896523, 2.0397697e-05) (-0.00056919893, 2.0082595e-05) (-0.0005694478, 1.9779339e-05) (-0.00056971126, 1.948866e-05) (-0.00056998866, 1.9211259e-05) (-0.00057027934, 1.8947803e-05) (-0.0005705826, 1.8698928e-05) (-0.0005708977, 1.8465232e-05) (-0.00057122389, 1.8247279e-05) (-0.00057156038, 1.8045594e-05) (-0.00057190636, 1.7860663e-05) (-0.000572261, 1.7692931e-05) (-0.00057262344, 1.7542802e-05) (-0.00057299281, 1.7410639e-05) (-0.00057336823, 1.7296759e-05) (-0.00057374877, 1.7201436e-05) (-0.00057413354, 1.7124902e-05) (-0.0005745216, 1.7067338e-05) (-0.00057491201, 1.7028886e-05) (-0.00057540194, 1.7004817e-05) (-0.00057559818, 1.7e-05) (-0.00061940182, 1.7e-05) (-0.00061959806, 1.7004817e-05) (-0.00062008799, 1.7028886e-05) (-0.0006204784, 1.7067338e-05) (-0.00062086646, 1.7124902e-05) (-0.00062125123, 1.7201436e-05) (-0.00062163177, 1.7296759e-05) (-0.00062200719, 1.7410639e-05) (-0.00062237656, 1.7542802e-05) (-0.000622739, 1.7692931e-05) (-0.00062309364, 1.7860663e-05) (-0.00062343962, 1.8045594e-05) (-0.00062377611, 1.8247279e-05) (-0.0006241023, 1.8465232e-05) (-0.0006244174, 1.8698928e-05) (-0.00062472066, 1.8947803e-05) (-0.00062501134, 1.9211259e-05) (-0.00062528874, 1.948866e-05) (-0.0006255522, 1.9779339e-05) (-0.00062580107, 2.0082595e-05) (-0.00062603477, 2.0397697e-05) (-0.00062625272, 2.0723887e-05) (-0.00062645441, 2.1060378e-05) (-0.00062663934, 2.140636e-05) (-0.00062680707, 2.1760999e-05) (-0.0006269572, 2.2123441e-05) (-0.00062708936, 2.2492814e-05) (-0.00062720324, 2.2868226e-05)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, closed, covered)
  pocket_cin = polyline(z=0, xy: (-0.0007565, -0.0001615) (-0.0007565, 0.0001615) (-0.00075644222, 0.00016267621) (-0.00075626942, 0.00016384108) (-0.00075598328, 0.00016498342) (-0.00075558655, 0.0001660922) (-0.00075508306, 0.00016715676) (-0.00075447763, 0.00016816684) (-0.00075377612, 0.00016911272) (-0.00075298528, 0.00016998528) (-0.00075211272, 0.00017077612) (-0.00075116684, 0.00017147763) (-0.00075015676, 0.00017208306) (-0.0007490922, 0.00017258655) (-0.00074798342, 0.00017298328) (-0.00074684108, 0.00017326942) (-0.00074567621, 0.00017344222) (-0.0007445, 0.0001735) (-0.0005675, 0.0001735) (-0.00056632379, 0.00017344222) (-0.00056515892, 0.00017326942) (-0.00056401658, 0.00017298328) (-0.0005629078, 0.00017258655) (-0.00056184324, 0.00017208306) (-0.00056083316, 0.00017147763) (-0.00055988728, 0.00017077612) (-0.00055901472, 0.00016998528) (-0.00055822388, 0.00016911272) (-0.00055752237, 0.00016816684) (-0.00055691694, 0.00016715676) (-0.00055641345, 0.0001660922) (-0.00055601672, 0.00016498342) (-0.00055573058, 0.00016384108) (-0.00055555778, 0.00016267621) (-0.0005555, 0.0001615) (-0.0005555, -0.0001615) (-0.00055555778, -0.00016267621) (-0.00055573058, -0.00016384108) (-0.00055601672, -0.00016498342) (-0.00055641345, -0.0001660922) (-0.00055691694, -0.00016715676) (-0.00055752237, -0.00016816684) (-0.00055822388, -0.00016911272) (-0.00055901472, -0.00016998528) (-0.00055988728, -0.00017077612) (-0.00056083316, -0.00017147763) (-0.00056184324, -0.00017208306) (-0.0005629078, -0.00017258655) (-0.00056401658, -0.00017298328) (-0.00056515892, -0.00017326942) (-0.00056632379, -0.00017344222) (-0.0005675, -0.0001735) (-0.0007445, -0.0001735) (-0.00074567621, -0.00017344222) (-0.00074684108, -0.00017326942) (-0.00074798342, -0.00017298328) (-0.0007490922, -0.00017258655) (-0.00075015676, -0.00017208306) (-0.00075116684, -0.00017147763) (-0.00075211272, -0.00017077612) (-0.00075298528, -0.00016998528) (-0.00075377612, -0.00016911272) (-0.00075447763, -0.00016816684) (-0.00075508306, -0.00016715676) (-0.00075558655, -0.0001660922) (-0.00075598328, -0.00016498342) (-0.00075626942, -0.00016384108) (-0.00075644222, -0.00016267621) (-0.0007565, -0.0001615), closed, covered)
  tap_trace_n0 [copper] = polyline(z=0, xy: (0.00015, -8e-06) (-0.00015, -8e-06) (-0.00015, 8e-06) (-8e-06, 8e-06) (-8e-06, 0.0001) (8e-06, 0.0001) (8e-06, 8e-06) (0.00015, 8e-06) (0.00015, -8e-06), closed, covered)
  tap_cut_n0 = polyline(z=0, xy: (0.00015, -1.7e-05) (-0.00015, -1.7e-05) (-0.00015, 1.7e-05) (-1.7e-05, 1.7e-05) (-1.7e-05, 0.0001) (1.7e-05, 0.0001) (1.7e-05, 1.7e-05) (0.00015, 1.7e-05) (0.00015, -1.7e-05), closed, covered)
  plate_cp [copper] = polyline(z=0, xy: (9.25e-05, 0.00027) (9.2461478e-05, 0.00026921586) (9.2346282e-05, 0.00026843928) (9.2155523e-05, 0.00026767772) (9.1891036e-05, 0.00026693853) (9.155537e-05, 0.00026622883) (9.1151757e-05, 0.00026555544) (9.0684084e-05, 0.00026492485) (9.0156854e-05, 0.00026434315) (8.9575146e-05, 0.00026381592) (8.8944562e-05, 0.00026334824) (8.8271174e-05, 0.00026294463) (8.7561467e-05, 0.00026260896) (8.6822277e-05, 0.00026234448) (8.6060723e-05, 0.00026215372) (8.5284137e-05, 0.00026203852) (8.45e-05, 0.000262) (-8.45e-05, 0.000262) (-8.5284137e-05, 0.00026203852) (-8.6060723e-05, 0.00026215372) (-8.6822277e-05, 0.00026234448) (-8.7561467e-05, 0.00026260896) (-8.8271174e-05, 0.00026294463) (-8.8944562e-05, 0.00026334824) (-8.9575146e-05, 0.00026381592) (-9.0156854e-05, 0.00026434315) (-9.0684084e-05, 0.00026492485) (-9.1151757e-05, 0.00026555544) (-9.155537e-05, 0.00026622883) (-9.1891036e-05, 0.00026693853) (-9.2155523e-05, 0.00026767772) (-9.2346282e-05, 0.00026843928) (-9.2461478e-05, 0.00026921586) (-9.25e-05, 0.00027) (-9.25e-05, 0.000295) (-9.2461478e-05, 0.00029578414) (-9.2346282e-05, 0.00029656072) (-9.2155523e-05, 0.00029732228) (-9.1891036e-05, 0.00029806147) (-9.155537e-05, 0.00029877117) (-9.1151757e-05, 0.00029944456) (-9.0684084e-05, 0.00030007515) (-9.0156854e-05, 0.00030065685) (-8.9575146e-05, 0.00030118408) (-8.8944562e-05, 0.00030165176) (-8.8271174e-05, 0.00030205537) (-8.7561467e-05, 0.00030239104) (-8.6822277e-05, 0.00030265552) (-8.6060723e-05, 0.00030284628) (-8.5284137e-05, 0.00030296148) (-8.45e-05, 0.000303) (8.45e-05, 0.000303) (8.5284137e-05, 0.00030296148) (8.6060723e-05, 0.00030284628) (8.6822277e-05, 0.00030265552) (8.7561467e-05, 0.00030239104) (8.8271174e-05, 0.00030205537) (8.8944562e-05, 0.00030165176) (8.9575146e-05, 0.00030118408) (9.0156854e-05, 0.00030065685) (9.0684084e-05, 0.00030007515) (9.1151757e-05, 0.00029944456) (9.155537e-05, 0.00029877117) (9.1891036e-05, 0.00029806147) (9.2155523e-05, 0.00029732228) (9.2346282e-05, 0.00029656072) (9.2461478e-05, 0.00029578414) (9.25e-05, 0.000295) (9.25e-05, 0.00027), closed, covered)
  frame_cp [copper] = polyline(z=0, xy: (9.65e-05, 0.00025) (9.7284137e-05, 0.00025003852) (9.8060723e-05, 0.00025015372) (9.8822277e-05, 0.00025034448) (9.9561467e-05, 0.00025060896) (0.00010027117, 0.00025094463) (0.00010094456, 0.00025134824) (0.00010157515, 0.00025181592) (0.00010215685, 0.00025234315) (0.00010268408, 0.00025292485) (0.00010315176, 0.00025355544) (0.00010355537, 0.00025422883) (0.00010389104, 0.00025493853) (0.00010415552, 0.00025567772) (0.00010434628, 0.00025643928) (0.00010446148, 0.00025721586) (0.0001045, 0.000258) (0.0001045, 0.000307) (0.00010446148, 0.00030778414) (0.00010434628, 0.00030856072) (0.00010415552, 0.00030932228) (0.00010389104, 0.00031006147) (0.00010355537, 0.00031077117) (0.00010315176, 0.00031144456) (0.00010268408, 0.00031207515) (0.00010215685, 0.00031265685) (0.00010157515, 0.00031318408) (0.00010094456, 0.00031365176) (0.00010027117, 0.00031405537) (9.9561467e-05, 0.00031439104) (9.8822277e-05, 0.00031465552) (9.8060723e-05, 0.00031484628) (9.7284137e-05, 0.00031496148) (9.65e-05, 0.000315) (2.509818e-05, 0.000315) (2.4901939e-05, 0.00031500482) (2.4412015e-05, 0.00031502889) (2.40216e-05, 0.00031506734) (2.3633541e-05, 0.0003151249) (2.3248774e-05, 0.00031520144) (2.2868226e-05, 0.00031529676) (2.2492814e-05, 0.00031541064) (2.2123441e-05, 0.0003155428) (2.1760999e-05, 0.00031569293) (2.140636e-05, 0.00031586066) (2.1060378e-05, 0.00031604559) (2.0723887e-05, 0.00031624728) (2.0397697e-05, 0.00031646523) (2.0082595e-05, 0.00031669893) (1.9779339e-05, 0.0003169478) (1.948866e-05, 0.00031721126) (1.9211259e-05, 0.00031748866) (1.8947803e-05, 0.00031777934) (1.8698928e-05, 0.00031808259) (1.8465232e-05, 0.0003183977) (1.8247279e-05, 0.00031872389) (1.8045594e-05, 0.00031906038) (1.7860663e-05, 0.00031940636) (1.7692931e-05, 0.000319761) (1.7542802e-05, 0.00032012344) (1.7410639e-05, 0.00032049281) (1.7296759e-05, 0.00032086823) (1.7201436e-05, 0.00032124877) (1.7124902e-05, 0.00032163354) (1.7067338e-05, 0.0003220216) (1.7028886e-05, 0.00032241201) (1.7004817e-05, 0.00032290194) (1.7e-05, 0.00032309818) (1.7e-05, 0.00036690182) (1.7004817e-05, 0.00036709806) (1.7028886e-05, 0.00036758799) (1.7067338e-05, 0.0003679784) (1.7124902e-05, 0.00036836646) (1.7201436e-05, 0.00036875123) (1.7296759e-05, 0.00036913177) (1.7410639e-05, 0.00036950719) (1.7542802e-05, 0.00036987656) (1.7692931e-05, 0.000370239) (1.7860663e-05, 0.00037059364) (1.8045594e-05, 0.00037093962) (1.8247279e-05, 0.00037127611) (1.8465232e-05, 0.0003716023) (1.8698928e-05, 0.0003719174) (1.8947803e-05, 0.00037222066) (1.9211259e-05, 0.00037251134) (1.948866e-05, 0.00037278874) (1.9779339e-05, 0.0003730522) (2.0082595e-05, 0.00037330107) (2.0397697e-05, 0.00037353477) (2.0723887e-05, 0.00037375272) (2.1060378e-05, 0.00037395441) (2.140636e-05, 0.00037413934) (2.1760999e-05, 0.00037430707) (2.2123441e-05, 0.0003744572) (2.2492814e-05, 0.00037458936) (2.2868226e-05, 0.00037470324) (2.3248774e-05, 0.00037479856) (2.3633541e-05, 0.0003748751) (2.40216e-05, 0.00037493266) (2.4412015e-05, 0.00037497111) (2.4901939e-05, 0.00037499518) (2.509818e-05, 0.000375) (0.00015340182, 0.000375) (0.00015359806, 0.00037499518) (0.00015408799, 0.00037497111) (0.0001544784, 0.00037493266) (0.00015486646, 0.0003748751) (0.00015525123, 0.00037479856) (0.00015563177, 0.00037470324) (0.00015600719, 0.00037458936) (0.00015637656, 0.0003744572) (0.000156739, 0.00037430707) (0.00015709364, 0.00037413934) (0.00015743962, 0.00037395441) (0.00015777611, 0.00037375272) (0.0001581023, 0.00037353477) (0.00015841741, 0.00037330107) (0.00015872066, 0.0003730522) (0.00015901134, 0.00037278874) (0.00015928874, 0.00037251134) (0.0001595522, 0.00037222066) (0.00015980107, 0.0003719174) (0.00016003477, 0.0003716023) (0.00016025272, 0.00037127611) (0.00016045441, 0.00037093962) (0.00016063934, 0.00037059364) (0.00016080707, 0.000370239) (0.0001609572, 0.00036987656) (0.00016108936, 0.00036950719) (0.00016120324, 0.00036913177) (0.00016129856, 0.00036875123) (0.0001613751, 0.00036836646) (0.00016143266, 0.0003679784) (0.00016147111, 0.00036758799) (0.00016149518, 0.00036709806) (0.0001615, 0.00036690182) (0.0001615, 0.00020609818) (0.00016149518, 0.00020590194) (0.00016147111, 0.00020541201) (0.00016143266, 0.0002050216) (0.0001613751, 0.00020463354) (0.00016129856, 0.00020424877) (0.00016120324, 0.00020386823) (0.00016108936, 0.00020349281) (0.0001609572, 0.00020312344) (0.00016080707, 0.000202761) (0.00016063934, 0.00020240636) (0.00016045441, 0.00020206038) (0.00016025272, 0.00020172389) (0.00016003477, 0.0002013977) (0.00015980107, 0.0002010826) (0.0001595522, 0.00020077934) (0.00015928874, 0.00020048866) (0.00015901134, 0.00020021126) (0.00015872066, 0.0001999478) (0.00015841741, 0.00019969893) (0.0001581023, 0.00019946523) (0.00015777611, 0.00019924728) (0.00015743962, 0.00019904559) (0.00015709364, 0.00019886066) (0.000156739, 0.00019869293) (0.00015637656, 0.0001985428) (0.00015600719, 0.00019841064) (0.00015563177, 0.00019829676) (0.00015525123, 0.00019820144) (0.00015486646, 0.0001981249) (0.0001544784, 0.00019806734) (0.00015408799, 0.00019802889) (0.00015359806, 0.00019800482) (0.00015340182, 0.000198) (-0.00015340182, 0.000198) (-0.00015359806, 0.00019800482) (-0.00015408799, 0.00019802889) (-0.0001544784, 0.00019806734) (-0.00015486646, 0.0001981249) (-0.00015525123, 0.00019820144) (-0.00015563177, 0.00019829676) (-0.00015600719, 0.00019841064) (-0.00015637656, 0.0001985428) (-0.000156739, 0.00019869293) (-0.00015709364, 0.00019886066) (-0.00015743962, 0.00019904559) (-0.00015777611, 0.00019924728) (-0.0001581023, 0.00019946523) (-0.00015841741, 0.00019969893) (-0.00015872066, 0.0001999478) (-0.00015901134, 0.00020021126) (-0.00015928874, 0.00020048866) (-0.0001595522, 0.00020077934) (-0.00015980107, 0.0002010826) (-0.00016003477, 0.0002013977) (-0.00016025272, 0.00020172389) (-0.00016045441, 0.00020206038) (-0.00016063934, 0.00020240636) (-0.00016080707, 0.000202761) (-0.0001609572, 0.00020312344) (-0.00016108936, 0.00020349281) (-0.00016120324, 0.00020386823) (-0.00016129856, 0.00020424877) (-0.0001613751, 0.00020463354) (-0.00016143266, 0.0002050216) (-0.00016147111, 0.00020541201) (-0.00016149518, 0.00020590194) (-0.0001615, 0.00020609818) (-0.0001615, 0.00036690182) (-0.00016149518, 0.00036709806) (-0.00016147111, 0.00036758799) (-0.00016143266, 0.0003679784) (-0.0001613751, 0.00036836646) (-0.00016129856, 0.00036875123) (-0.00016120324, 0.00036913177) (-0.00016108936, 0.00036950719) (-0.0001609572, 0.00036987656) (-0.00016080707, 0.000370239) (-0.00016063934, 0.00037059364) (-0.00016045441, 0.00037093962) (-0.00016025272, 0.00037127611) (-0.00016003477, 0.0003716023) (-0.00015980107, 0.0003719174) (-0.0001595522, 0.00037222066) (-0.00015928874, 0.00037251134) (-0.00015901134, 0.00037278874) (-0.00015872066, 0.0003730522) (-0.00015841741, 0.00037330107) (-0.0001581023, 0.00037353477) (-0.00015777611, 0.00037375272) (-0.00015743962, 0.00037395441) (-0.00015709364, 0.00037413934) (-0.000156739, 0.00037430707) (-0.00015637656, 0.0003744572) (-0.00015600719, 0.00037458936) (-0.00015563177, 0.00037470324) (-0.00015525123, 0.00037479856) (-0.00015486646, 0.0003748751) (-0.0001544784, 0.00037493266) (-0.00015408799, 0.00037497111) (-0.00015359806, 0.00037499518) (-0.00015340182, 0.000375) (-2.509818e-05, 0.000375) (-2.4901939e-05, 0.00037499518) (-2.4412015e-05, 0.00037497111) (-2.40216e-05, 0.00037493266) (-2.3633541e-05, 0.0003748751) (-2.3248774e-05, 0.00037479856) (-2.2868226e-05, 0.00037470324) (-2.2492814e-05, 0.00037458936) (-2.2123441e-05, 0.0003744572) (-2.1760999e-05, 0.00037430707) (-2.140636e-05, 0.00037413934) (-2.1060378e-05, 0.00037395441) (-2.0723887e-05, 0.00037375272) (-2.0397697e-05, 0.00037353477) (-2.0082595e-05, 0.00037330107) (-1.9779339e-05, 0.0003730522) (-1.948866e-05, 0.00037278874) (-1.9211259e-05, 0.00037251134) (-1.8947803e-05, 0.00037222066) (-1.8698928e-05, 0.0003719174) (-1.8465232e-05, 0.0003716023) (-1.8247279e-05, 0.00037127611) (-1.8045594e-05, 0.00037093962) (-1.7860663e-05, 0.00037059364) (-1.7692931e-05, 0.000370239) (-1.7542802e-05, 0.00036987656) (-1.7410639e-05, 0.00036950719) (-1.7296759e-05, 0.00036913177) (-1.7201436e-05, 0.00036875123) (-1.7124902e-05, 0.00036836646) (-1.7067338e-05, 0.0003679784) (-1.7028886e-05, 0.00036758799) (-1.7004817e-05, 0.00036709806) (-1.7e-05, 0.00036690182) (-1.7e-05, 0.00032309818) (-1.7004817e-05, 0.00032290194) (-1.7028886e-05, 0.00032241201) (-1.7067338e-05, 0.0003220216) (-1.7124902e-05, 0.00032163354) (-1.7201436e-05, 0.00032124877) (-1.7296759e-05, 0.00032086823) (-1.7410639e-05, 0.00032049281) (-1.7542802e-05, 0.00032012344) (-1.7692931e-05, 0.000319761) (-1.7860663e-05, 0.00031940636) (-1.8045594e-05, 0.00031906038) (-1.8247279e-05, 0.00031872389) (-1.8465232e-05, 0.0003183977) (-1.8698928e-05, 0.00031808259) (-1.8947803e-05, 0.00031777934) (-1.9211259e-05, 0.00031748866) (-1.948866e-05, 0.00031721126) (-1.9779339e-05, 0.0003169478) (-2.0082595e-05, 0.00031669893) (-2.0397697e-05, 0.00031646523) (-2.0723887e-05, 0.00031624728) (-2.1060378e-05, 0.00031604559) (-2.140636e-05, 0.00031586066) (-2.1760999e-05, 0.00031569293) (-2.2123441e-05, 0.0003155428) (-2.2492814e-05, 0.00031541064) (-2.2868226e-05, 0.00031529676)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, closed, covered)
  pocket_cp = polyline(z=0, xy: (0.0001615, 0.000186) (-0.0001615, 0.000186) (-0.00016267621, 0.00018605778) (-0.00016384108, 0.00018623058) (-0.00016498342, 0.00018651672) (-0.0001660922, 0.00018691345) (-0.00016715676, 0.00018741695) (-0.00016816684, 0.00018802236) (-0.00016911272, 0.00018872387) (-0.00016998528, 0.00018951472) (-0.00017077612, 0.00019038728) (-0.00017147763, 0.00019133316) (-0.00017208306, 0.00019234324) (-0.00017258655, 0.0001934078) (-0.00017298328, 0.00019451658) (-0.00017326942, 0.00019565892) (-0.00017344222, 0.00019682379) (-0.0001735, 0.000198) (-0.0001735, 0.000375) (-0.00017344222, 0.00037617621) (-0.00017326942, 0.00037734108) (-0.00017298328, 0.00037848342) (-0.00017258655, 0.0003795922) (-0.00017208306, 0.00038065676) (-0.00017147763, 0.00038166684) (-0.00017077612, 0.00038261272) (-0.00016998528, 0.00038348528) (-0.00016911272, 0.00038427613) (-0.00016816684, 0.00038497764) (-0.00016715676, 0.00038558305) (-0.0001660922, 0.00038608655) (-0.00016498342, 0.00038648328) (-0.00016384108, 0.00038676942) (-0.00016267621, 0.00038694222) (-0.0001615, 0.000387) (0.0001615, 0.000387) (0.00016267621, 0.00038694222) (0.00016384108, 0.00038676942) (0.00016498342, 0.00038648328) (0.0001660922, 0.00038608655) (0.00016715676, 0.00038558305) (0.00016816684, 0.00038497764) (0.00016911272, 0.00038427613) (0.00016998528, 0.00038348528) (0.00017077612, 0.00038261272) (0.00017147763, 0.00038166684) (0.00017208306, 0.00038065676) (0.00017258655, 0.0003795922) (0.00017298328, 0.00037848342) (0.00017326942, 0.00037734108) (0.00017344222, 0.00037617621) (0.0001735, 0.000375) (0.0001735, 0.000198) (0.00017344222, 0.00019682379) (0.00017326942, 0.00019565892) (0.00017298328, 0.00019451658) (0.00017258655, 0.0001934078) (0.00017208306, 0.00019234324) (0.00017147763, 0.00019133316) (0.00017077612, 0.00019038728) (0.00016998528, 0.00018951472) (0.00016911272, 0.00018872387) (0.00016816684, 0.00018802236) (0.00016715676, 0.00018741695) (0.0001660922, 0.00018691345) (0.00016498342, 0.00018651672) (0.00016384108, 0.00018623058) (0.00016267621, 0.00018605778) (0.0001615, 0.000186), closed, covered)
  tap_trace_jf [copper] = polyline(z=0, xy: (-8e-06, 0.001465) (-8e-06, 0.001765) (8e-06, 0.001765) (8e-06, 0.001623) (0.000127, 0.001623) (0.000127, 0.001607) (8e-06, 0.001607) (8e-06, 0.001465) (-8e-06, 0.001465), closed, covered)
  tap_cut_jf = polyline(z=0, xy: (-1.7e-05, 0.001465) (-1.7e-05, 0.001765) (1.7e-05, 0.001765) (1.7e-05, 0.001632) (0.000127, 0.001632) (0.000127, 0.001598) (1.7e-05, 0.001598) (1.7e-05, 0.001465) (-1.7e-05, 0.001465), closed, covered)
  tap_trace_jr [copper] = polyline(z=0, xy: (0.000273, 0.001623) (0.000392, 0.001623) (0.000392, 0.001765) (0.000408, 0.001765) (0.000408, 0.001465) (0.000392, 0.001465) (0.000392, 0.001607) (0.000273, 0.001607) (0.000273, 0.001623), closed, covered)
  tap_cut_jr = polyline(z=0, xy: (0.000273, 0.001632) (0.000383, 0.001632) (0.000383, 0.001765) (0.000417, 0.001765) (0.000417, 0.001465) (0.000383, 0.001465) (0.000383, 0.001598) (0.000273, 0.001598) (0.000273, 0.001632), closed, covered)
  head_a_cj [copper] = polyline(z=0, xy: (0.000159, 0.0015825) (0.00015880397, 0.0015825096) (0.00015860982, 0.0015825384) (0.00015841943, 0.0015825861) (0.00015823463, 0.0015826522) (0.00015805721, 0.0015827362) (0.00015788886, 0.0015828371) (0.00015773121, 0.001582954) (0.00015758579, 0.0015830858) (0.00015745398, 0.0015832312) (0.00015733706, 0.0015833889) (0.00015723616, 0.0015835572) (0.00015715224, 0.0015837346) (0.00015708612, 0.0015839194) (0.00015703843, 0.0015841098) (0.00015700963, 0.001584304) (0.000157, 0.0015845) (0.000157, 0.0016455) (0.00015700963, 0.001645696) (0.00015703843, 0.0016458902) (0.00015708612, 0.0016460806) (0.00015715224, 0.0016462654) (0.00015723616, 0.0016464428) (0.00015733706, 0.0016466111) (0.00015745398, 0.0016467688) (0.00015758579, 0.0016469142) (0.00015773121, 0.001647046) (0.00015788886, 0.0016471629) (0.00015805721, 0.0016472638) (0.00015823463, 0.0016473478) (0.00015841943, 0.0016474139) (0.00015860982, 0.0016474616) (0.00015880397, 0.0016474904) (0.000159, 0.0016475) (0.00018, 0.0016475) (0.00018019603, 0.0016474904) (0.00018039018, 0.0016474616) (0.00018058057, 0.0016474139) (0.00018076537, 0.0016473478) (0.00018094279, 0.0016472638) (0.00018111114, 0.0016471629) (0.00018126879, 0.001647046) (0.00018141421, 0.0016469142) (0.00018154602, 0.0016467688) (0.00018166294, 0.0016466111) (0.00018176384, 0.0016464428) (0.00018184776, 0.0016462654) (0.00018191388, 0.0016460806) (0.00018196157, 0.0016458902) (0.00018199037, 0.001645696) (0.000182, 0.0016455) (0.000182, 0.0015845) (0.00018199037, 0.001584304) (0.00018196157, 0.0015841098) (0.00018191388, 0.0015839194) (0.00018184776, 0.0015837346) (0.00018176384, 0.0015835572) (0.00018166294, 0.0015833889) (0.00018154602, 0.0015832312) (0.00018141421, 0.0015830858) (0.00018126879, 0.001582954) (0.00018111114, 0.0015828371) (0.00018094279, 0.0015827362) (0.00018076537, 0.0015826522) (0.00018058057, 0.0015825861) (0.00018039018, 0.0015825384) (0.00018019603, 0.0015825096) (0.00018, 0.0015825) (0.000159, 0.0015825), closed, covered)
  head_b_cj [copper] = polyline(z=0, xy: (0.00022, 0.0015825) (0.00021980397, 0.0015825096) (0.00021960982, 0.0015825384) (0.00021941943, 0.0015825861) (0.00021923463, 0.0015826522) (0.00021905721, 0.0015827362) (0.00021888886, 0.0015828371) (0.00021873121, 0.001582954) (0.00021858579, 0.0015830858) (0.00021845398, 0.0015832312) (0.00021833706, 0.0015833889) (0.00021823616, 0.0015835572) (0.00021815224, 0.0015837346) (0.00021808612, 0.0015839194) (0.00021803843, 0.0015841098) (0.00021800963, 0.001584304) (0.000218, 0.0015845) (0.000218, 0.0016455) (0.00021800963, 0.001645696) (0.00021803843, 0.0016458902) (0.00021808612, 0.0016460806) (0.00021815224, 0.0016462654) (0.00021823616, 0.0016464428) (0.00021833706, 0.0016466111) (0.00021845398, 0.0016467688) (0.00021858579, 0.0016469142) (0.00021873121, 0.001647046) (0.00021888886, 0.0016471629) (0.00021905721, 0.0016472638) (0.00021923463, 0.0016473478) (0.00021941943, 0.0016474139) (0.00021960982, 0.0016474616) (0.00021980397, 0.0016474904) (0.00022, 0.0016475) (0.000241, 0.0016475) (0.00024119603, 0.0016474904) (0.00024139018, 0.0016474616) (0.00024158057, 0.0016474139) (0.00024176537, 0.0016473478) (0.00024194279, 0.0016472638) (0.00024211114, 0.0016471629) (0.00024226879, 0.001647046) (0.00024241421, 0.0016469142) (0.00024254602, 0.0016467688) (0.00024266294, 0.0016466111) (0.00024276384, 0.0016464428) (0.00024284776, 0.0016462654) (0.00024291388, 0.0016460806) (0.00024296157, 0.0016458902) (0.00024299037, 0.001645696) (0.000243, 0.0016455) (0.000243, 0.0015845) (0.00024299037, 0.001584304) (0.00024296157, 0.0015841098) (0.00024291388, 0.0015839194) (0.00024284776, 0.0015837346) (0.00024276384, 0.0015835572) (0.00024266294, 0.0015833889) (0.00024254602, 0.0015832312) (0.00024241421, 0.0015830858) (0.00024226879, 0.001582954) (0.00024211114, 0.0015828371) (0.00024194279, 0.0015827362) (0.00024176537, 0.0015826522) (0.00024158057, 0.0015825861) (0.00024139018, 0.0015825384) (0.00024119603, 0.0015825096) (0.000241, 0.0015825) (0.00022, 0.0015825), closed, covered)
  pocket_cj = polyline(z=0, xy: (0.000143, 0.0015665) (0.00014280397, 0.0015665096) (0.00014260982, 0.0015665384) (0.00014241943, 0.0015665861) (0.00014223463, 0.0015666522) (0.00014205721, 0.0015667362) (0.00014188886, 0.0015668371) (0.00014173121, 0.001566954) (0.00014158579, 0.0015670858) (0.00014145398, 0.0015672312) (0.00014133706, 0.0015673889) (0.00014123616, 0.0015675572) (0.00014115224, 0.0015677346) (0.00014108612, 0.0015679194) (0.00014103843, 0.0015681098) (0.00014100963, 0.001568304) (0.000141, 0.0015685) (0.000141, 0.0016615) (0.00014100963, 0.001661696) (0.00014103843, 0.0016618902) (0.00014108612, 0.0016620806) (0.00014115224, 0.0016622654) (0.00014123616, 0.0016624428) (0.00014133706, 0.0016626111) (0.00014145398, 0.0016627688) (0.00014158579, 0.0016629142) (0.00014173121, 0.001663046) (0.00014188886, 0.0016631629) (0.00014205721, 0.0016632638) (0.00014223463, 0.0016633478) (0.00014241943, 0.0016634139) (0.00014260982, 0.0016634616) (0.00014280397, 0.0016634904) (0.000143, 0.0016635) (0.000257, 0.0016635) (0.00025719603, 0.0016634904) (0.00025739018, 0.0016634616) (0.00025758057, 0.0016634139) (0.00025776537, 0.0016633478) (0.00025794279, 0.0016632638) (0.00025811114, 0.0016631629) (0.00025826879, 0.001663046) (0.00025841421, 0.0016629142) (0.00025854602, 0.0016627688) (0.00025866294, 0.0016626111) (0.00025876384, 0.0016624428) (0.00025884776, 0.0016622654) (0.00025891388, 0.0016620806) (0.00025896157, 0.0016618902) (0.00025899037, 0.001661696) (0.000259, 0.0016615) (0.000259, 0.0015685) (0.00025899037, 0.001568304) (0.00025896157, 0.0015681098) (0.00025891388, 0.0015679194) (0.00025884776, 0.0015677346) (0.00025876384, 0.0015675572) (0.00025866294, 0.0015673889) (0.00025854602, 0.0015672312) (0.00025841421, 0.0015670858) (0.00025826879, 0.001566954) (0.00025811114, 0.0015668371) (0.00025794279, 0.0015667362) (0.00025776537, 0.0015666522) (0.00025758057, 0.0015665861) (0.00025739018, 0.0015665384) (0.00025719603, 0.0015665096) (0.000257, 0.0015665) (0.000143, 0.0015665), closed, covered)
  open_to_ground_readout_open = rectangle(corner=(0.000383, 0.002915, 0), x_size=3.4e-05, y_size=6e-06)
  endcap_filter_tail_end = rectangle(corner=(-0.0008146, 0.0012909213, 0), x_size=2.92e-05, y_size=9.6e-06)
  endcap_res_tail_end = rectangle(corner=(0.0007854, 0.0029225638, 0), x_size=2.92e-05, y_size=9.6e-06)
  ground_main_plane [copper] = rectangle(corner=(-0.0022485, -0.0003765, 0), x_size=0.004497, y_size=0.0034990638)
  main [silicon_eps11p5] = box(corner=(-0.0022485, -0.0003765, -0.0005), size=(0.004497, 0.0034990638, 0.0005))
  ground_main_plane.subtract(cut_feed_jf, cut_stub_p, cut_feed_mid, endcap_res_tail_end, cut_feed_out, cut_res_open_run, tap_cut_n0, lead_a_sub_cp, lead_b_sub_cp, lead_a_sub_cin, cut_stub_f, cut_feed_in, lead_a_sub_cj, tap_cut_jf, lead_b_sub_cin, tap_cut_jr, lead_b_sub_cj, pocket_LPPin, open_to_ground_readout_open, pocket_LPPout, pocket_cin, cut_filter_tail, endcap_filter_tail_end, pocket_cp, cut_res_tail, pocket_cj, cut_stub_r)
boundaries and excitations:
  ThinCond1: ThinConductor Objects=[lead_a_cin, lead_b_cin, lead_a_cp, lead_b_cp, trace_feed_in, trace_feed_mid, trace_feed_out, trace_stub_p, lead_a_cj, lead_b_cj, trace_stub_f, trace_stub_r, trace_feed_jf, trace_res_open_run, trace_filter_tail, trace_res_tail, launch_pad_LPPin, launch_pad_LPPout, plate_cin, frame_cin, tap_trace_n0, plate_cp, frame_cp, tap_trace_jf, tap_trace_jr, head_a_cj, head_b_cj, ground_main_plane] Material=pec Thickness=200nm
  frame_cin: SignalNet Objects=[lead_a_cin, trace_feed_in, launch_pad_LPPin, frame_cin]
  frame_cp: SignalNet Objects=[lead_b_cin, lead_a_cp, trace_feed_mid, trace_feed_out, trace_stub_p, launch_pad_LPPout, plate_cin, tap_trace_n0, frame_cp]
  head_a_cj: SignalNet Objects=[lead_b_cp, lead_a_cj, trace_stub_f, trace_feed_jf, trace_filter_tail, plate_cp, tap_trace_jf, head_a_cj]
  head_b_cj: SignalNet Objects=[lead_b_cj, trace_stub_r, trace_res_open_run, trace_res_tail, tap_trace_jr, head_b_cj]
  g_wb: SignalNet Objects=[g_wb, g_wb_1..g_wb_29, ground_main_plane]
setups:
  Setup: Matrix AdaptiveFreq=6.5GHz Cap{MaxPass=8 MinPass=2 MinConvPass=2 PerError=0.3 PerRefine=30 AutoIncreaseSolutionOrder SolutionOrder=Normal Solver_Type=Iterative}
source amplitudes:
  frame_cin: Cap 1V 0deg
  frame_cp, g_wb, head_a_cj, head_b_cj: Cap 0V 0deg

design Q400g42_1653_q3d (Q3D Extractor, model units mm)
options: SParamCalcMethod=EqTransLine Calculate_Lossy_Dielectrics
geometry:
  lead_a_cin_path = polyline((-0.000744499, 0, 0) (-0.0007925, 0, 0))
  lead_a_cin [copper] = polyline((-0.000744499, -8e-06, 0) (-0.000744499, 8e-06, 0))
  lead_a_cin.sweep_along_path(lead_a_cin_path)
  lead_a_sub_cin_path = polyline((-0.000744499, 0, 0) (-0.0007925, 0, 0))
  lead_a_sub_cin = polyline((-0.000744499, -1.7e-05, 0) (-0.000744499, 1.7e-05, 0))
  lead_a_sub_cin.sweep_along_path(lead_a_sub_cin_path)
  lead_b_cin_path = polyline((-0.000639501, 0, 0) (-0.0005275, 0, 0))
  lead_b_cin [copper] = polyline((-0.000639501, 8e-06, 0) (-0.000639501, -8e-06, 0))
  lead_b_cin.sweep_along_path(lead_b_cin_path)
  lead_b_sub_cin_path = polyline((-0.000639501, 0, 0) (-0.0005275, 0, 0))
  lead_b_sub_cin = polyline((-0.000639501, 1.7e-05, 0) (-0.000639501, -1.7e-05, 0))
  lead_b_sub_cin.sweep_along_path(lead_b_sub_cin_path)
  lead_a_cp_path = polyline((0, 0.000198001, 0) (0, 0.00015, 0))
  lead_a_cp [copper] = polyline((8e-06, 0.000198001, 0) (-8e-06, 0.000198001, 0))
  lead_a_cp.sweep_along_path(lead_a_cp_path)
  lead_a_sub_cp_path = polyline((0, 0.000198001, 0) (0, 0.00015, 0))
  lead_a_sub_cp = polyline((1.7e-05, 0.000198001, 0) (-1.7e-05, 0.000198001, 0))
  lead_a_sub_cp.sweep_along_path(lead_a_sub_cp_path)
  lead_b_cp_path = polyline((0, 0.000302999, 0) (0, 0.000415, 0))
  lead_b_cp [copper] = polyline((-8e-06, 0.000302999, 0) (8e-06, 0.000302999, 0))
  lead_b_cp.sweep_along_path(lead_b_cp_path)
  lead_b_sub_cp_path = polyline((0, 0.000302999, 0) (0, 0.000415, 0))
  lead_b_sub_cp = polyline((-1.7e-05, 0.000302999, 0) (1.7e-05, 0.000302999, 0))
  lead_b_sub_cp.sweep_along_path(lead_b_sub_cp_path)
  trace_feed_in_path = polyline((-0.00162, 0, 0) (-0.0007925, 0, 0))
  trace_feed_in [copper] = polyline((-0.00162, 8e-06, 0) (-0.00162, -8e-06, 0))
  trace_feed_in.sweep_along_path(trace_feed_in_path)
  cut_feed_in_path = polyline((-0.00162, 0, 0) (-0.0007925, 0, 0))
  cut_feed_in = polyline((-0.00162, 1.7e-05, 0) (-0.00162, -1.7e-05, 0))
  cut_feed_in.sweep_along_path(cut_feed_in_path)
  trace_feed_mid_path = polyline((-0.0005275, 0, 0) (-0.00015, 0, 0))
  trace_feed_mid [copper] = polyline((-0.0005275, 8e-06, 0) (-0.0005275, -8e-06, 0))
  trace_feed_mid.sweep_along_path(trace_feed_mid_path)
  cut_feed_mid_path = polyline((-0.0005275, 0, 0) (-0.00015, 0, 0))
  cut_feed_mid = polyline((-0.0005275, 1.7e-05, 0) (-0.0005275, -1.7e-05, 0))
  cut_feed_mid.sweep_along_path(cut_feed_mid_path)
  trace_feed_out_path = polyline((0.00015, 0, 0) (0.00162, 0, 0))
  trace_feed_out [copper] = polyline((0.00015, 8e-06, 0) (0.00015, -8e-06, 0))
  trace_feed_out.sweep_along_path(trace_feed_out_path)
  cut_feed_out_path = polyline((0.00015, 0, 0) (0.00162, 0, 0))
  cut_feed_out = polyline((0.00015, 1.7e-05, 0) (0.00015, -1.7e-05, 0))
  cut_feed_out.sweep_along_path(cut_feed_out_path)
  trace_stub_p_path = polyline((0, 0.0001, 0) (0, 0.00015, 0))
  trace_stub_p [copper] = polyline((-8e-06, 0.0001, 0) (8e-06, 0.0001, 0))
  trace_stub_p.sweep_along_path(trace_stub_p_path)
  cut_stub_p_path = polyline((0, 0.0001, 0) (0, 0.00015, 0))
  cut_stub_p = polyline((-1.7e-05, 0.0001, 0) (1.7e-05, 0.0001, 0))
  cut_stub_p.sweep_along_path(cut_stub_p_path)
  lead_a_cj_path = polyline((0.000154001, 0.001615, 0) (0.000144, 0.001615, 0))
  lead_a_cj [copper] = polyline((0.000154001, 0.001607, 0) (0.000154001, 0.001623, 0))
  lead_a_cj.sweep_along_path(lead_a_cj_path)
  lead_a_sub_cj_path = polyline((0.000154001, 0.001615, 0) (0.000144, 0.001615, 0))
  lead_a_sub_cj = polyline((0.000154001, 0.001598, 0) (0.000154001, 0.001632, 0))
  lead_a_sub_cj.sweep_along_path(lead_a_sub_cj_path)
  lead_b_cj_path = polyline((0.000245999, 0.001615, 0) (0.000256, 0.001615, 0))
  lead_b_cj [copper] = polyline((0.000245999, 0.001623, 0) (0.000245999, 0.001607, 0))
  lead_b_cj.sweep_along_path(lead_b_cj_path)
  lead_b_sub_cj_path = polyline((0.000245999, 0.001615, 0) (0.000256, 0.001615, 0))
  lead_b_sub_cj = polyline((0.000245999, 0.001632, 0) (0.000245999, 0.001598, 0))
  lead_b_sub_cj.sweep_along_path(lead_b_sub_cj_path)
  trace_stub_f_path = polyline((0.000124, 0.001615, 0) (0.000144, 0.001615, 0))
  trace_stub_f [copper] = polyline((0.000124, 0.001623, 0) (0.000124, 0.001607, 0))
  trace_stub_f.sweep_along_path(trace_stub_f_path)
  cut_stub_f_path = polyline((0.000124, 0.001615, 0) (0.000144, 0.001615, 0))
  cut_stub_f = polyline((0.000124, 0.001632, 0) (0.000124, 0.001598, 0))
  cut_stub_f.sweep_along_path(cut_stub_f_path)
  trace_stub_r_path = polyline((0.000256, 0.001615, 0) (0.000276, 0.001615, 0))
  trace_stub_r [copper] = polyline((0.000256, 0.001623, 0) (0.000256, 0.001607, 0))
  trace_stub_r.sweep_along_path(trace_stub_r_path)
  cut_stub_r_path = polyline((0.000256, 0.001615, 0) (0.000276, 0.001615, 0))
  cut_stub_r = polyline((0.000256, 0.001632, 0) (0.000256, 0.001598, 0))
  cut_stub_r.sweep_along_path(cut_stub_r_path)
  trace_feed_jf_path = polyline((0, 0.000415, 0) (0, 0.001465, 0))
  trace_feed_jf [copper] = polyline((-8e-06, 0.000415, 0) (8e-06, 0.000415, 0))
  trace_feed_jf.sweep_along_path(trace_feed_jf_path)
  cut_feed_jf_path = polyline((0, 0.000415, 0) (0, 0.001465, 0))
  cut_feed_jf = polyline((-1.7e-05, 0.000415, 0) (1.7e-05, 0.000415, 0))
  cut_feed_jf.sweep_along_path(cut_feed_jf_path)
  trace_res_open_run_path = polyline((0.0004, 0.001765, 0) (0.0004, 0.002915, 0))
  trace_res_open_run [copper] = polyline((0.000392, 0.001765, 0) (0.000408, 0.001765, 0))
  trace_res_open_run.sweep_along_path(trace_res_open_run_path)
  cut_res_open_run_path = polyline((0.0004, 0.001765, 0) (0.0004, 0.002915, 0))
  cut_res_open_run = polyline((0.000383, 0.001765, 0) (0.000417, 0.001765, 0))
  cut_res_open_run.sweep_along_path(cut_res_open_run_path)
  trace_filter_tail_path = polyline(z=0, xy: (0, 0.001765) (0, 0.002165) (-0.0004, 0.002165) (-0.0004, 0.00065) (-0.0008, 0.00065) (-0.0008, 0.0012909213))
  trace_filter_tail_path.fillet(Vertices=trace_filter_tail_path.vertex(2 of 6, 3 of 6, 4 of 6, 5 of 6) Radius=9.9e-05 Setback=0mm)
  trace_filter_tail [copper] = polyline((-8e-06, 0.001765, 0) (8e-06, 0.001765, 0))
  trace_filter_tail.sweep_along_path(trace_filter_tail_path)
  cut_filter_tail_path = polyline(z=0, xy: (0, 0.001765) (0, 0.002165) (-0.0004, 0.002165) (-0.0004, 0.00065) (-0.0008, 0.00065) (-0.0008, 0.0012909213))
  cut_filter_tail_path.fillet(Vertices=cut_filter_tail_path.vertex(2 of 6, 3 of 6, 4 of 6, 5 of 6) Radius=9.9e-05 Setback=0mm)
  cut_filter_tail = polyline((-1.7e-05, 0.001765, 0) (1.7e-05, 0.001765, 0))
  cut_filter_tail.sweep_along_path(cut_filter_tail_path)
  trace_res_tail_path = polyline(z=0, xy: (0.0004, 0.001465) (0.0004, 0.00065) (0.0008, 0.00065) (0.0008, 0.0029225638))
  trace_res_tail_path.fillet(Vertices=trace_res_tail_path.vertex(2 of 4, 3 of 4) Radius=9.9e-05 Setback=0mm)
  trace_res_tail [copper] = polyline((0.000408, 0.001465, 0) (0.000392, 0.001465, 0))
  trace_res_tail.sweep_along_path(trace_res_tail_path)
  cut_res_tail_path = polyline(z=0, xy: (0.0004, 0.001465) (0.0004, 0.00065) (0.0008, 0.00065) (0.0008, 0.0029225638))
  cut_res_tail_path.fillet(Vertices=cut_res_tail_path.vertex(2 of 4, 3 of 4) Radius=9.9e-05 Setback=0mm)
  cut_res_tail = polyline((0.000417, 0.001465, 0) (0.000383, 0.001465, 0))
  cut_res_tail.sweep_along_path(cut_res_tail_path)
  g_wb [pec] = bondwire(WireType=LOW WireDiameter=0.015mm NumSides=6 XPadPos=-0.0013441667 YPadPos=-3.4e-05 ZPadPos=0 XDir=0 YDir=1 ZDir=0 Distance=6.8e-05 h1=6.8e-05 h2=0mm alpha=80deg beta=80deg WhichAxis=Z)
  g_wb_1 [pec] = bondwire(WireType=LOW WireDiameter=0.015mm NumSides=6 XPadPos=-0.0010683333 YPadPos=-3.4e-05 ZPadPos=0 XDir=0 YDir=1 ZDir=0 Distance=6.8e-05 h1=6.8e-05 h2=0mm alpha=80deg beta=80deg WhichAxis=Z)
  g_wb_2 [pec] = bondwire(WireType=LOW WireDiameter=0.015mm NumSides=6 XPadPos=-0.00033875 YPadPos=-3.4e-05 ZPadPos=0 XDir=0 YDir=1 ZDir=0 Distance=6.8e-05 h1=6.8e-05 h2=0mm alpha=80deg beta=80deg WhichAxis=Z)
  g_wb_3 [pec] = bondwire(WireType=LOW WireDiameter=0.015mm NumSides=6 XPadPos=0.000444 YPadPos=-3.4e-05 ZPadPos=0 XDir=0 YDir=1 ZDir=0 Distance=6.8e-05 h1=6.8e-05 h2=0mm alpha=80deg beta=80deg WhichAxis=Z)
  g_wb_4 [pec] = bondwire(WireType=LOW WireDiameter=0.015mm NumSides=6 XPadPos=0.000738 YPadPos=-3.4e-05 ZPadPos=0 XDir=0 YDir=1 ZDir=0 Distance=6.8e-05 h1=6.8e-05 h2=0mm alpha=80deg beta=80deg WhichAxis=Z)
  g_wb_5 [pec] = bondwire(WireType=LOW WireDiameter=0.015mm NumSides=6 XPadPos=0.001032 YPadPos=-3.4e-05 ZPadPos=0 XDir=0 YDir=1 ZDir=0 Distance=6.8e-05 h1=6.8e-05 h2=0mm alpha=80deg beta=80deg WhichAxis=Z)
  g_wb_6 [pec] = bondwire(WireType=LOW WireDiameter=0.015mm NumSides=6 XPadPos=0.001326 YPadPos=-3.4e-05 ZPadPos=0 XDir=0 YDir=1 ZDir=0 Distance=6.8e-05 h1=6.8e-05 h2=0mm alpha=80deg beta=80deg WhichAxis=Z)
  g_wb_7 [pec] = bondwire(WireType=LOW WireDiameter=0.015mm NumSides=6 XPadPos=3.4e-05 YPadPos=0.0006775 ZPadPos=0 XDir=-1 YDir=0 ZDir=0 Distance=6.8e-05 h1=6.8e-05 h2=0mm alpha=80deg beta=80deg WhichAxis=Z)
  g_wb_8 [pec] = bondwire(WireType=LOW WireDiameter=0.015mm NumSides=6 XPadPos=3.4e-05 YPadPos=0.00094 ZPadPos=0 XDir=-1 YDir=0 ZDir=0 Distance=6.8e-05 h1=6.8e-05 h2=0mm alpha=80deg beta=80deg WhichAxis=Z)
  g_wb_9 [pec] = bondwire(WireType=LOW WireDiameter=0.015mm NumSides=6 XPadPos=3.4e-05 YPadPos=0.0012025 ZPadPos=0 XDir=-1 YDir=0 ZDir=0 Distance=6.8e-05 h1=6.8e-05 h2=0mm alpha=80deg beta=80deg WhichAxis=Z)
  g_wb_10 [pec] = bondwire(WireType=LOW WireDiameter=0.015mm NumSides=6 XPadPos=0.000434 YPadPos=0.0020525 ZPadPos=0 XDir=-1 YDir=0 ZDir=0 Distance=6.8e-05 h1=6.8e-05 h2=0mm alpha=80deg beta=80deg WhichAxis=Z)
  g_wb_11 [pec] = bondwire(WireType=LOW WireDiameter=0.015mm NumSides=6 XPadPos=0.000434 YPadPos=0.00234 ZPadPos=0 XDir=-1 YDir=0 ZDir=0 Distance=6.8e-05 h1=6.8e-05 h2=0mm alpha=80deg beta=80deg WhichAxis=Z)
  g_wb_12 [pec] = bondwire(WireType=LOW WireDiameter=0.015mm NumSides=6 XPadPos=0.000434 YPadPos=0.0026275 ZPadPos=0 XDir=-1 YDir=0 ZDir=0 Distance=6.8e-05 h1=6.8e-05 h2=0mm alpha=80deg beta=80deg WhichAxis=Z)
  g_wb_13 [pec] = bondwire(WireType=LOW WireDiameter=0.015mm NumSides=6 XPadPos=3.4e-05 YPadPos=0.001965 ZPadPos=0 XDir=-1 YDir=0 ZDir=0 Distance=6.8e-05 h1=6.8e-05 h2=0mm alpha=80deg beta=80deg WhichAxis=Z)
  g_wb_14 [pec] = bondwire(WireType=LOW WireDiameter=0.015mm NumSides=6 XPadPos=-0.0002 YPadPos=0.002199 ZPadPos=0 XDir=0 YDir=-1 ZDir=0 Distance=6.8e-05 h1=6.8e-05 h2=0mm alpha=80deg beta=80deg WhichAxis=Z)
  g_wb_15 [pec] = bondwire(WireType=LOW WireDiameter=0.015mm NumSides=6 XPadPos=-0.000434 YPadPos=0.001862 ZPadPos=0 XDir=1 YDir=0 ZDir=0 Distance=6.8e-05 h1=6.8e-05 h2=0mm alpha=80deg beta=80deg WhichAxis=Z)
  g_wb_16 [pec] = bondwire(WireType=LOW WireDiameter=0.015mm NumSides=6 XPadPos=-0.000434 YPadPos=0.001559 ZPadPos=0 XDir=1 YDir=0 ZDir=0 Distance=6.8e-05 h1=6.8e-05 h2=0mm alpha=80deg beta=80deg WhichAxis=Z)
  g_wb_17 [pec] = bondwire(WireType=LOW WireDiameter=0.015mm NumSides=6 XPadPos=-0.000434 YPadPos=0.001256 ZPadPos=0 XDir=1 YDir=0 ZDir=0 Distance=6.8e-05 h1=6.8e-05 h2=0mm alpha=80deg beta=80deg WhichAxis=Z)
  g_wb_18 [pec] = bondwire(WireType=LOW WireDiameter=0.015mm NumSides=6 XPadPos=-0.000434 YPadPos=0.000953 ZPadPos=0 XDir=1 YDir=0 ZDir=0 Distance=6.8e-05 h1=6.8e-05 h2=0mm alpha=80deg beta=80deg WhichAxis=Z)
  g_wb_19 [pec] = bondwire(WireType=LOW WireDiameter=0.015mm NumSides=6 XPadPos=-0.0006 YPadPos=0.000684 ZPadPos=0 XDir=0 YDir=-1 ZDir=0 Distance=6.8e-05 h1=6.8e-05 h2=0mm alpha=80deg beta=80deg WhichAxis=Z)
  g_wb_20 [pec] = bondwire(WireType=LOW WireDiameter=0.015mm NumSides=6 XPadPos=-0.000766 YPadPos=0.00097046066 ZPadPos=0 XDir=-1 YDir=0 ZDir=0 Distance=6.8e-05 h1=6.8e-05 h2=0mm alpha=80deg beta=80deg WhichAxis=Z)
  g_wb_21 [pec] = bondwire(WireType=LOW WireDiameter=0.015mm NumSides=6 XPadPos=0.000366 YPadPos=0.0011933333 ZPadPos=0 XDir=1 YDir=0 ZDir=0 Distance=6.8e-05 h1=6.8e-05 h2=0mm alpha=80deg beta=80deg WhichAxis=Z)
  g_wb_22 [pec] = bondwire(WireType=LOW WireDiameter=0.015mm NumSides=6 XPadPos=0.000366 YPadPos=0.00092166667 ZPadPos=0 XDir=1 YDir=0 ZDir=0 Distance=6.8e-05 h1=6.8e-05 h2=0mm alpha=80deg beta=80deg WhichAxis=Z)
  g_wb_23 [pec] = bondwire(WireType=LOW WireDiameter=0.015mm NumSides=6 XPadPos=0.0006 YPadPos=0.000616 ZPadPos=0 XDir=0 YDir=1 ZDir=0 Distance=6.8e-05 h1=6.8e-05 h2=0mm alpha=80deg beta=80deg WhichAxis=Z)
  g_wb_24 [pec] = bondwire(WireType=LOW WireDiameter=0.015mm NumSides=6 XPadPos=0.000834 YPadPos=0.00097465197 ZPadPos=0 XDir=-1 YDir=0 ZDir=0 Distance=6.8e-05 h1=6.8e-05 h2=0mm alpha=80deg beta=80deg WhichAxis=Z)
  g_wb_25 [pec] = bondwire(WireType=LOW WireDiameter=0.015mm NumSides=6 XPadPos=0.000834 YPadPos=0.0012993039 ZPadPos=0 XDir=-1 YDir=0 ZDir=0 Distance=6.8e-05 h1=6.8e-05 h2=0mm alpha=80deg beta=80deg WhichAxis=Z)
  g_wb_26 [pec] = bondwire(WireType=LOW WireDiameter=0.015mm NumSides=6 XPadPos=0.000834 YPadPos=0.0016239559 ZPadPos=0 XDir=-1 YDir=0 ZDir=0 Distance=6.8e-05 h1=6.8e-05 h2=0mm alpha=80deg beta=80deg WhichAxis=Z)
  g_wb_27 [pec] = bondwire(WireType=LOW WireDiameter=0.015mm NumSides=6 XPadPos=0.000834 YPadPos=0.0019486079 ZPadPos=0 XDir=-1 YDir=0 ZDir=0 Distance=6.8e-05 h1=6.8e-05 h2=0mm alpha=80deg beta=80deg WhichAxis=Z)
  g_wb_28 [pec] = bondwire(WireType=LOW WireDiameter=0.015mm NumSides=6 XPadPos=0.000834 YPadPos=0.0022732598 ZPadPos=0 XDir=-1 YDir=0 ZDir=0 Distance=6.8e-05 h1=6.8e-05 h2=0mm alpha=80deg beta=80deg WhichAxis=Z)
  g_wb_29 [pec] = bondwire(WireType=LOW WireDiameter=0.015mm NumSides=6 XPadPos=0.000834 YPadPos=0.0025979118 ZPadPos=0 XDir=-1 YDir=0 ZDir=0 Distance=6.8e-05 h1=6.8e-05 h2=0mm alpha=80deg beta=80deg WhichAxis=Z)
  launch_pad_LPPin [copper] = polyline(z=0, xy: (-0.00165, 8e-06) (-0.001772, 0.0001) (-0.001972, 0.0001) (-0.001972, -0.0001) (-0.001772, -0.0001) (-0.00165, -8e-06) (-0.00162, -8e-06) (-0.00162, 8e-06) (-0.00165, 8e-06), closed, covered)
  pocket_LPPin = polyline(z=0, xy: (-0.00165, 1.7e-05) (-0.001772, 0.0001765) (-0.0020485, 0.0001765) (-0.0020485, -0.0001765) (-0.001772, -0.0001765) (-0.00165, -1.7e-05) (-0.00162, -1.7e-05) (-0.00162, 1.7e-05) (-0.00165, 1.7e-05), closed, covered)
  launch_pad_LPPout [copper] = polyline(z=0, xy: (0.00165, -8e-06) (0.001772, -0.0001) (0.001972, -0.0001) (0.001972, 0.0001) (0.001772, 0.0001) (0.00165, 8e-06) (0.00162, 8e-06) (0.00162, -8e-06) (0.00165, -8e-06), closed, covered)
  pocket_LPPout = polyline(z=0, xy: (0.00165, -1.7e-05) (0.001772, -0.0001765) (0.0020485, -0.0001765) (0.0020485, 0.0001765) (0.001772, 0.0001765) (0.00165, 1.7e-05) (0.00162, 1.7e-05) (0.00162, -1.7e-05) (0.00165, -1.7e-05), closed, covered)
  plate_cin [copper] = polyline(z=0, xy: (-0.0006725, -9.1e-05) (-0.00067328414, -9.0961478e-05) (-0.00067406072, -9.0846282e-05) (-0.00067482228, -9.0655523e-05) (-0.00067556147, -9.0391036e-05) (-0.00067627117, -9.005537e-05) (-0.00067694456, -8.9651757e-05) (-0.00067757515, -8.9184084e-05) (-0.00067815685, -8.8656854e-05) (-0.00067868408, -8.8075146e-05) (-0.00067915176, -8.7444562e-05) (-0.00067955537, -8.6771174e-05) (-0.00067989104, -8.6061467e-05) (-0.00068015552, -8.5322277e-05) (-0.00068034628, -8.4560723e-05) (-0.00068046148, -8.3784137e-05) (-0.0006805, -8.3e-05) (-0.0006805, 8.3e-05) (-0.00068046148, 8.3784137e-05) (-0.00068034628, 8.4560723e-05) (-0.00068015552, 8.5322277e-05) (-0.00067989104, 8.6061467e-05) (-0.00067955537, 8.6771174e-05) (-0.00067915176, 8.7444562e-05) (-0.00067868408, 8.8075146e-05) (-0.00067815685, 8.8656854e-05) (-0.00067757515, 8.9184084e-05) (-0.00067694456, 8.9651757e-05) (-0.00067627117, 9.005537e-05) (-0.00067556147, 9.0391036e-05) (-0.00067482228, 9.0655523e-05) (-0.00067406072, 9.0846282e-05) (-0.00067328414, 9.0961478e-05) (-0.0006725, 9.1e-05) (-0.0006475, 9.1e-05) (-0.00064671586, 9.0961478e-05) (-0.00064593928, 9.0846282e-05) (-0.00064517772, 9.0655523e-05) (-0.00064443853, 9.0391036e-05) (-0.00064372883, 9.005537e-05) (-0.00064305544, 8.9651757e-05) (-0.00064242485, 8.9184084e-05) (-0.00064184315, 8.8656854e-05) (-0.00064131592, 8.8075146e-05) (-0.00064084824, 8.7444562e-05) (-0.00064044463, 8.6771174e-05) (-0.00064010896, 8.6061467e-05) (-0.00063984448, 8.5322277e-05) (-0.00063965372, 8.4560723e-05) (-0.00063953852, 8.3784137e-05) (-0.0006395, 8.3e-05) (-0.0006395, -8.3e-05) (-0.00063953852, -8.3784137e-05) (-0.00063965372, -8.4560723e-05) (-0.00063984448, -8.5322277e-05) (-0.00064010896, -8.6061467e-05) (-0.00064044463, -8.6771174e-05) (-0.00064084824, -8.7444562e-05) (-0.00064131592, -8.8075146e-05) (-0.00064184315, -8.8656854e-05) (-0.00064242485, -8.9184084e-05) (-0.00064305544, -8.9651757e-05) (-0.00064372883, -9.005537e-05) (-0.00064443853, -9.0391036e-05) (-0.00064517772, -9.0655523e-05) (-0.00064593928, -9.0846282e-05) (-0.00064671586, -9.0961478e-05) (-0.0006475, -9.1e-05) (-0.0006725, -9.1e-05), closed, covered)
  frame_cin [copper] = polyline(z=0, xy: (-0.0006925, -9.5e-05) (-0.00069246148, -9.5784137e-05) (-0.00069234628, -9.6560723e-05) (-0.00069215552, -9.7322277e-05) (-0.00069189104, -9.8061467e-05) (-0.00069155537, -9.8771174e-05) (-0.00069115176, -9.9444562e-05) (-0.00069068408, -0.00010007515) (-0.00069015685, -0.00010065685) (-0.00068957515, -0.00010118408) (-0.00068894456, -0.00010165176) (-0.00068827117, -0.00010205537) (-0.00068756147, -0.00010239104) (-0.00068682228, -0.00010265552) (-0.00068606072, -0.00010284628) (-0.00068528414, -0.00010296148) (-0.0006845, -0.000103) (-0.0006355, -0.000103) (-0.00063471586, -0.00010296148) (-0.00063393928, -0.00010284628) (-0.00063317772, -0.00010265552) (-0.00063243853, -0.00010239104) (-0.00063172883, -0.00010205537) (-0.00063105544, -0.00010165176) (-0.00063042485, -0.00010118408) (-0.00062984315, -0.00010065685) (-0.00062931592, -0.00010007515) (-0.00062884824, -9.9444562e-05) (-0.00062844463, -9.8771174e-05) (-0.00062810896, -9.8061467e-05) (-0.00062784448, -9.7322277e-05) (-0.00062765372, -9.6560723e-05) (-0.00062753852, -9.5784137e-05) (-0.0006275, -9.5e-05) (-0.0006275, -2.509818e-05) (-0.00062749518, -2.4901939e-05) (-0.00062747111, -2.4412015e-05) (-0.00062743266, -2.40216e-05) (-0.0006273751, -2.3633541e-05) (-0.00062729856, -2.3248774e-05) (-0.00062720324, -2.2868226e-05) (-0.00062708936, -2.2492814e-05) (-0.0006269572, -2.2123441e-05) (-0.00062680707, -2.1760999e-05) (-0.00062663934, -2.140636e-05) (-0.00062645441, -2.1060378e-05) (-0.00062625272, -2.0723887e-05) (-0.00062603477, -2.0397697e-05) (-0.00062580107, -2.0082595e-05) (-0.0006255522, -1.9779339e-05) (-0.00062528874, -1.948866e-05) (-0.00062501134, -1.9211259e-05) (-0.00062472066, -1.8947803e-05) (-0.0006244174, -1.8698928e-05) (-0.0006241023, -1.8465232e-05) (-0.00062377611, -1.8247279e-05) (-0.00062343962, -1.8045594e-05) (-0.00062309364, -1.7860663e-05) (-0.000622739, -1.7692931e-05) (-0.00062237656, -1.7542802e-05) (-0.00062200719, -1.7410639e-05) (-0.00062163177, -1.7296759e-05) (-0.00062125123, -1.7201436e-05) (-0.00062086646, -1.7124902e-05) (-0.0006204784, -1.7067338e-05) (-0.00062008799, -1.7028886e-05) (-0.00061959806, -1.7004817e-05) (-0.00061940182, -1.7e-05) (-0.00057559818, -1.7e-05) (-0.00057540194, -1.7004817e-05) (-0.00057491201, -1.7028886e-05) (-0.0005745216, -1.7067338e-05) (-0.00057413354, -1.7124902e-05) (-0.00057374877, -1.7201436e-05) (-0.00057336823, -1.7296759e-05) (-0.00057299281, -1.7410639e-05) (-0.00057262344, -1.7542802e-05) (-0.000572261, -1.7692931e-05) (-0.00057190636, -1.7860663e-05) (-0.00057156038, -1.8045594e-05) (-0.00057122389, -1.8247279e-05) (-0.0005708977, -1.8465232e-05) (-0.0005705826, -1.8698928e-05) (-0.00057027934, -1.8947803e-05) (-0.00056998866, -1.9211259e-05) (-0.00056971126, -1.948866e-05) (-0.0005694478, -1.9779339e-05) (-0.00056919893, -2.0082595e-05) (-0.00056896523, -2.0397697e-05) (-0.00056874728, -2.0723887e-05) (-0.00056854559, -2.1060378e-05) (-0.00056836066, -2.140636e-05) (-0.00056819293, -2.1760999e-05) (-0.0005680428, -2.2123441e-05) (-0.00056791064, -2.2492814e-05) (-0.00056779676, -2.2868226e-05) (-0.00056770144, -2.3248774e-05) (-0.0005676249, -2.3633541e-05) (-0.00056756734, -2.40216e-05) (-0.00056752889, -2.4412015e-05) (-0.00056750482, -2.4901939e-05) (-0.0005675, -2.509818e-05) (-0.0005675, -0.00015190182) (-0.00056750482, -0.00015209806) (-0.00056752889, -0.00015258799) (-0.00056756734, -0.0001529784) (-0.0005676249, -0.00015336646) (-0.00056770144, -0.00015375123) (-0.00056779676, -0.00015413177) (-0.00056791064, -0.00015450719) (-0.0005680428, -0.00015487656) (-0.00056819293, -0.000155239) (-0.00056836066, -0.00015559364) (-0.00056854559, -0.00015593962) (-0.00056874728, -0.00015627611) (-0.00056896523, -0.0001566023) (-0.00056919893, -0.0001569174) (-0.0005694478, -0.00015722066) (-0.00056971126, -0.00015751134) (-0.00056998866, -0.00015778874) (-0.00057027934, -0.0001580522) (-0.0005705826, -0.00015830107) (-0.0005708977, -0.00015853477) (-0.00057122389, -0.00015875272) (-0.00057156038, -0.00015895441) (-0.00057190636, -0.00015913934) (-0.000572261, -0.00015930707) (-0.00057262344, -0.0001594572) (-0.00057299281, -0.00015958936) (-0.00057336823, -0.00015970324) (-0.00057374877, -0.00015979856) (-0.00057413354, -0.0001598751) (-0.0005745216, -0.00015993266) (-0.00057491201, -0.00015997111) (-0.00057540194, -0.00015999518) (-0.00057559818, -0.00016) (-0.00073640182, -0.00016) (-0.00073659806, -0.00015999518) (-0.00073708798, -0.00015997111) (-0.0007374784, -0.00015993266) (-0.00073786646, -0.0001598751) (-0.00073825123, -0.00015979856) (-0.00073863177, -0.00015970324) (-0.00073900719, -0.00015958936) (-0.00073937656, -0.0001594572) (-0.000739739, -0.00015930707) (-0.00074009364, -0.00015913934) (-0.00074043962, -0.00015895441) (-0.00074077611, -0.00015875272) (-0.0007411023, -0.00015853477) (-0.0007414174, -0.00015830107) (-0.00074172066, -0.0001580522) (-0.00074201134, -0.00015778874) (-0.00074228874, -0.00015751134) (-0.0007425522, -0.00015722066) (-0.00074280107, -0.0001569174) (-0.00074303477, -0.0001566023) (-0.00074325272, -0.00015627611) (-0.00074345441, -0.00015593962) (-0.00074363934, -0.00015559364) (-0.00074380707, -0.000155239) (-0.0007439572, -0.00015487656) (-0.00074408936, -0.00015450719) (-0.00074420324, -0.00015413177) (-0.00074429856, -0.00015375123) (-0.0007443751, -0.00015336646) (-0.00074443266, -0.0001529784) (-0.00074447111, -0.00015258799) (-0.00074449518, -0.00015209806) (-0.0007445, -0.00015190182) (-0.0007445, 0.00015190182) (-0.00074449518, 0.00015209806) (-0.00074447111, 0.00015258799) (-0.00074443266, 0.0001529784) (-0.0007443751, 0.00015336646) (-0.00074429856, 0.00015375123) (-0.00074420324, 0.00015413177) (-0.00074408936, 0.00015450719) (-0.0007439572, 0.00015487656) (-0.00074380707, 0.000155239) (-0.00074363934, 0.00015559364) (-0.00074345441, 0.00015593962) (-0.00074325272, 0.00015627611) (-0.00074303477, 0.0001566023) (-0.00074280107, 0.0001569174) (-0.0007425522, 0.00015722066) (-0.00074228874, 0.00015751134) (-0.00074201134, 0.00015778874) (-0.00074172066, 0.0001580522) (-0.0007414174, 0.00015830107) (-0.0007411023, 0.00015853477) (-0.00074077611, 0.00015875272) (-0.00074043962, 0.00015895441) (-0.00074009364, 0.00015913934) (-0.000739739, 0.00015930707) (-0.00073937656, 0.0001594572) (-0.00073900719, 0.00015958936) (-0.00073863177, 0.00015970324) (-0.00073825123, 0.00015979856) (-0.00073786646, 0.0001598751) (-0.0007374784, 0.00015993266) (-0.00073708798, 0.00015997111) (-0.00073659806, 0.00015999518) (-0.00073640182, 0.00016) (-0.00057559818, 0.00016) (-0.00057540194, 0.00015999518) (-0.00057491201, 0.00015997111) (-0.0005745216, 0.00015993266) (-0.00057413354, 0.0001598751) (-0.00057374877, 0.00015979856) (-0.00057336823, 0.00015970324) (-0.00057299281, 0.00015958936) (-0.00057262344, 0.0001594572) (-0.000572261, 0.00015930707) (-0.00057190636, 0.00015913934) (-0.00057156038, 0.00015895441) (-0.00057122389, 0.00015875272) (-0.0005708977, 0.00015853477) (-0.0005705826, 0.00015830107) (-0.00057027934, 0.0001580522) (-0.00056998866, 0.00015778874) (-0.00056971126, 0.00015751134) (-0.0005694478, 0.00015722066) (-0.00056919893, 0.0001569174) (-0.00056896523, 0.0001566023) (-0.00056874728, 0.00015627611) (-0.00056854559, 0.00015593962) (-0.00056836066, 0.00015559364) (-0.00056819293, 0.000155239) (-0.0005680428, 0.00015487656) (-0.00056791064, 0.00015450719) (-0.00056779676, 0.00015413177) (-0.00056770144, 0.00015375123) (-0.0005676249, 0.00015336646) (-0.00056756734, 0.0001529784) (-0.00056752889, 0.00015258799) (-0.00056750482, 0.00015209806) (-0.0005675, 0.00015190182) (-0.0005675, 2.509818e-05) (-0.00056750482, 2.4901939e-05) (-0.00056752889, 2.4412015e-05) (-0.00056756734, 2.40216e-05) (-0.0005676249, 2.3633541e-05) (-0.00056770144, 2.3248774e-05) (-0.00056779676, 2.2868226e-05) (-0.00056791064, 2.2492814e-05) (-0.0005680428, 2.2123441e-05) (-0.00056819293, 2.1760999e-05) (-0.00056836066, 2.140636e-05) (-0.00056854559, 2.1060378e-05) (-0.00056874728, 2.0723887e-05) (-0.00056896523, 2.0397697e-05) (-0.00056919893, 2.0082595e-05) (-0.0005694478, 1.9779339e-05) (-0.00056971126, 1.948866e-05) (-0.00056998866, 1.9211259e-05) (-0.00057027934, 1.8947803e-05) (-0.0005705826, 1.8698928e-05) (-0.0005708977, 1.8465232e-05) (-0.00057122389, 1.8247279e-05) (-0.00057156038, 1.8045594e-05) (-0.00057190636, 1.7860663e-05) (-0.000572261, 1.7692931e-05) (-0.00057262344, 1.7542802e-05) (-0.00057299281, 1.7410639e-05) (-0.00057336823, 1.7296759e-05) (-0.00057374877, 1.7201436e-05) (-0.00057413354, 1.7124902e-05) (-0.0005745216, 1.7067338e-05) (-0.00057491201, 1.7028886e-05) (-0.00057540194, 1.7004817e-05) (-0.00057559818, 1.7e-05) (-0.00061940182, 1.7e-05) (-0.00061959806, 1.7004817e-05) (-0.00062008799, 1.7028886e-05) (-0.0006204784, 1.7067338e-05) (-0.00062086646, 1.7124902e-05) (-0.00062125123, 1.7201436e-05) (-0.00062163177, 1.7296759e-05) (-0.00062200719, 1.7410639e-05) (-0.00062237656, 1.7542802e-05) (-0.000622739, 1.7692931e-05) (-0.00062309364, 1.7860663e-05) (-0.00062343962, 1.8045594e-05) (-0.00062377611, 1.8247279e-05) (-0.0006241023, 1.8465232e-05) (-0.0006244174, 1.8698928e-05) (-0.00062472066, 1.8947803e-05) (-0.00062501134, 1.9211259e-05) (-0.00062528874, 1.948866e-05) (-0.0006255522, 1.9779339e-05) (-0.00062580107, 2.0082595e-05) (-0.00062603477, 2.0397697e-05) (-0.00062625272, 2.0723887e-05) (-0.00062645441, 2.1060378e-05) (-0.00062663934, 2.140636e-05) (-0.00062680707, 2.1760999e-05) (-0.0006269572, 2.2123441e-05) (-0.00062708936, 2.2492814e-05) (-0.00062720324, 2.2868226e-05)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, closed, covered)
  pocket_cin = polyline(z=0, xy: (-0.0007565, -0.00016) (-0.0007565, 0.00016) (-0.00075644222, 0.00016117621) (-0.00075626942, 0.00016234108) (-0.00075598328, 0.00016348342) (-0.00075558655, 0.0001645922) (-0.00075508306, 0.00016565676) (-0.00075447763, 0.00016666684) (-0.00075377612, 0.00016761272) (-0.00075298528, 0.00016848528) (-0.00075211272, 0.00016927613) (-0.00075116684, 0.00016997764) (-0.00075015676, 0.00017058306) (-0.0007490922, 0.00017108655) (-0.00074798342, 0.00017148328) (-0.00074684108, 0.00017176942) (-0.00074567621, 0.00017194222) (-0.0007445, 0.000172) (-0.0005675, 0.000172) (-0.00056632379, 0.00017194222) (-0.00056515892, 0.00017176942) (-0.00056401658, 0.00017148328) (-0.0005629078, 0.00017108655) (-0.00056184324, 0.00017058306) (-0.00056083316, 0.00016997764) (-0.00055988728, 0.00016927613) (-0.00055901472, 0.00016848528) (-0.00055822388, 0.00016761272) (-0.00055752237, 0.00016666684) (-0.00055691694, 0.00016565676) (-0.00055641345, 0.0001645922) (-0.00055601672, 0.00016348342) (-0.00055573058, 0.00016234108) (-0.00055555778, 0.00016117621) (-0.0005555, 0.00016) (-0.0005555, -0.00016) (-0.00055555778, -0.00016117621) (-0.00055573058, -0.00016234108) (-0.00055601672, -0.00016348342) (-0.00055641345, -0.0001645922) (-0.00055691694, -0.00016565676) (-0.00055752237, -0.00016666684) (-0.00055822388, -0.00016761272) (-0.00055901472, -0.00016848528) (-0.00055988728, -0.00016927613) (-0.00056083316, -0.00016997764) (-0.00056184324, -0.00017058306) (-0.0005629078, -0.00017108655) (-0.00056401658, -0.00017148328) (-0.00056515892, -0.00017176942) (-0.00056632379, -0.00017194222) (-0.0005675, -0.000172) (-0.0007445, -0.000172) (-0.00074567621, -0.00017194222) (-0.00074684108, -0.00017176942) (-0.00074798342, -0.00017148328) (-0.0007490922, -0.00017108655) (-0.00075015676, -0.00017058306) (-0.00075116684, -0.00016997764) (-0.00075211272, -0.00016927613) (-0.00075298528, -0.00016848528) (-0.00075377612, -0.00016761272) (-0.00075447763, -0.00016666684) (-0.00075508306, -0.00016565676) (-0.00075558655, -0.0001645922) (-0.00075598328, -0.00016348342) (-0.00075626942, -0.00016234108) (-0.00075644222, -0.00016117621) (-0.0007565, -0.00016), closed, covered)
  tap_trace_n0 [copper] = polyline(z=0, xy: (0.00015, -8e-06) (-0.00015, -8e-06) (-0.00015, 8e-06) (-8e-06, 8e-06) (-8e-06, 0.0001) (8e-06, 0.0001) (8e-06, 8e-06) (0.00015, 8e-06) (0.00015, -8e-06), closed, covered)
  tap_cut_n0 = polyline(z=0, xy: (0.00015, -1.7e-05) (-0.00015, -1.7e-05) (-0.00015, 1.7e-05) (-1.7e-05, 1.7e-05) (-1.7e-05, 0.0001) (1.7e-05, 0.0001) (1.7e-05, 1.7e-05) (0.00015, 1.7e-05) (0.00015, -1.7e-05), closed, covered)
  plate_cp [copper] = polyline(z=0, xy: (9.1e-05, 0.00027) (9.0961478e-05, 0.00026921586) (9.0846282e-05, 0.00026843928) (9.0655523e-05, 0.00026767772) (9.0391036e-05, 0.00026693853) (9.005537e-05, 0.00026622883) (8.9651757e-05, 0.00026555544) (8.9184084e-05, 0.00026492485) (8.8656854e-05, 0.00026434315) (8.8075146e-05, 0.00026381592) (8.7444562e-05, 0.00026334824) (8.6771174e-05, 0.00026294463) (8.6061467e-05, 0.00026260896) (8.5322277e-05, 0.00026234448) (8.4560723e-05, 0.00026215372) (8.3784137e-05, 0.00026203852) (8.3e-05, 0.000262) (-8.3e-05, 0.000262) (-8.3784137e-05, 0.00026203852) (-8.4560723e-05, 0.00026215372) (-8.5322277e-05, 0.00026234448) (-8.6061467e-05, 0.00026260896) (-8.6771174e-05, 0.00026294463) (-8.7444562e-05, 0.00026334824) (-8.8075146e-05, 0.00026381592) (-8.8656854e-05, 0.00026434315) (-8.9184084e-05, 0.00026492485) (-8.9651757e-05, 0.00026555544) (-9.005537e-05, 0.00026622883) (-9.0391036e-05, 0.00026693853) (-9.0655523e-05, 0.00026767772) (-9.0846282e-05, 0.00026843928) (-9.0961478e-05, 0.00026921586) (-9.1e-05, 0.00027) (-9.1e-05, 0.000295) (-9.0961478e-05, 0.00029578414) (-9.0846282e-05, 0.00029656072) (-9.0655523e-05, 0.00029732228) (-9.0391036e-05, 0.00029806147) (-9.005537e-05, 0.00029877117) (-8.9651757e-05, 0.00029944456) (-8.9184084e-05, 0.00030007515) (-8.8656854e-05, 0.00030065685) (-8.8075146e-05, 0.00030118408) (-8.7444562e-05, 0.00030165176) (-8.6771174e-05, 0.00030205537) (-8.6061467e-05, 0.00030239104) (-8.5322277e-05, 0.00030265552) (-8.4560723e-05, 0.00030284628) (-8.3784137e-05, 0.00030296148) (-8.3e-05, 0.000303) (8.3e-05, 0.000303) (8.3784137e-05, 0.00030296148) (8.4560723e-05, 0.00030284628) (8.5322277e-05, 0.00030265552) (8.6061467e-05, 0.00030239104) (8.6771174e-05, 0.00030205537) (8.7444562e-05, 0.00030165176) (8.8075146e-05, 0.00030118408) (8.8656854e-05, 0.00030065685) (8.9184084e-05, 0.00030007515) (8.9651757e-05, 0.00029944456) (9.005537e-05, 0.00029877117) (9.0391036e-05, 0.00029806147) (9.0655523e-05, 0.00029732228) (9.0846282e-05, 0.00029656072) (9.0961478e-05, 0.00029578414) (9.1e-05, 0.000295) (9.1e-05, 0.00027), closed, covered)
  frame_cp [copper] = polyline(z=0, xy: (9.5e-05, 0.00025) (9.5784137e-05, 0.00025003852) (9.6560723e-05, 0.00025015372) (9.7322277e-05, 0.00025034448) (9.8061467e-05, 0.00025060896) (9.8771174e-05, 0.00025094463) (9.9444562e-05, 0.00025134824) (0.00010007515, 0.00025181592) (0.00010065685, 0.00025234315) (0.00010118408, 0.00025292485) (0.00010165176, 0.00025355544) (0.00010205537, 0.00025422883) (0.00010239104, 0.00025493853) (0.00010265552, 0.00025567772) (0.00010284628, 0.00025643928) (0.00010296148, 0.00025721586) (0.000103, 0.000258) (0.000103, 0.000307) (0.00010296148, 0.00030778414) (0.00010284628, 0.00030856072) (0.00010265552, 0.00030932228) (0.00010239104, 0.00031006147) (0.00010205537, 0.00031077117) (0.00010165176, 0.00031144456) (0.00010118408, 0.00031207515) (0.00010065685, 0.00031265685) (0.00010007515, 0.00031318408) (9.9444562e-05, 0.00031365176) (9.8771174e-05, 0.00031405537) (9.8061467e-05, 0.00031439104) (9.7322277e-05, 0.00031465552) (9.6560723e-05, 0.00031484628) (9.5784137e-05, 0.00031496148) (9.5e-05, 0.000315) (2.509818e-05, 0.000315) (2.4901939e-05, 0.00031500482) (2.4412015e-05, 0.00031502889) (2.40216e-05, 0.00031506734) (2.3633541e-05, 0.0003151249) (2.3248774e-05, 0.00031520144) (2.2868226e-05, 0.00031529676) (2.2492814e-05, 0.00031541064) (2.2123441e-05, 0.0003155428) (2.1760999e-05, 0.00031569293) (2.140636e-05, 0.00031586066) (2.1060378e-05, 0.00031604559) (2.0723887e-05, 0.00031624728) (2.0397697e-05, 0.00031646523) (2.0082595e-05, 0.00031669893) (1.9779339e-05, 0.0003169478) (1.948866e-05, 0.00031721126) (1.9211259e-05, 0.00031748866) (1.8947803e-05, 0.00031777934) (1.8698928e-05, 0.00031808259) (1.8465232e-05, 0.0003183977) (1.8247279e-05, 0.00031872389) (1.8045594e-05, 0.00031906038) (1.7860663e-05, 0.00031940636) (1.7692931e-05, 0.000319761) (1.7542802e-05, 0.00032012344) (1.7410639e-05, 0.00032049281) (1.7296759e-05, 0.00032086823) (1.7201436e-05, 0.00032124877) (1.7124902e-05, 0.00032163354) (1.7067338e-05, 0.0003220216) (1.7028886e-05, 0.00032241201) (1.7004817e-05, 0.00032290194) (1.7e-05, 0.00032309818) (1.7e-05, 0.00036690182) (1.7004817e-05, 0.00036709806) (1.7028886e-05, 0.00036758799) (1.7067338e-05, 0.0003679784) (1.7124902e-05, 0.00036836646) (1.7201436e-05, 0.00036875123) (1.7296759e-05, 0.00036913177) (1.7410639e-05, 0.00036950719) (1.7542802e-05, 0.00036987656) (1.7692931e-05, 0.000370239) (1.7860663e-05, 0.00037059364) (1.8045594e-05, 0.00037093962) (1.8247279e-05, 0.00037127611) (1.8465232e-05, 0.0003716023) (1.8698928e-05, 0.0003719174) (1.8947803e-05, 0.00037222066) (1.9211259e-05, 0.00037251134) (1.948866e-05, 0.00037278874) (1.9779339e-05, 0.0003730522) (2.0082595e-05, 0.00037330107) (2.0397697e-05, 0.00037353477) (2.0723887e-05, 0.00037375272) (2.1060378e-05, 0.00037395441) (2.140636e-05, 0.00037413934) (2.1760999e-05, 0.00037430707) (2.2123441e-05, 0.0003744572) (2.2492814e-05, 0.00037458936) (2.2868226e-05, 0.00037470324) (2.3248774e-05, 0.00037479856) (2.3633541e-05, 0.0003748751) (2.40216e-05, 0.00037493266) (2.4412015e-05, 0.00037497111) (2.4901939e-05, 0.00037499518) (2.509818e-05, 0.000375) (0.00015190182, 0.000375) (0.00015209806, 0.00037499518) (0.00015258799, 0.00037497111) (0.0001529784, 0.00037493266) (0.00015336646, 0.0003748751) (0.00015375123, 0.00037479856) (0.00015413177, 0.00037470324) (0.00015450719, 0.00037458936) (0.00015487656, 0.0003744572) (0.000155239, 0.00037430707) (0.00015559364, 0.00037413934) (0.00015593962, 0.00037395441) (0.00015627611, 0.00037375272) (0.0001566023, 0.00037353477) (0.0001569174, 0.00037330107) (0.00015722066, 0.0003730522) (0.00015751134, 0.00037278874) (0.00015778874, 0.00037251134) (0.0001580522, 0.00037222066) (0.00015830107, 0.0003719174) (0.00015853477, 0.0003716023) (0.00015875272, 0.00037127611) (0.00015895441, 0.00037093962) (0.00015913934, 0.00037059364) (0.00015930707, 0.000370239) (0.0001594572, 0.00036987656) (0.00015958936, 0.00036950719) (0.00015970324, 0.00036913177) (0.00015979856, 0.00036875123) (0.0001598751, 0.00036836646) (0.00015993266, 0.0003679784) (0.00015997111, 0.00036758799) (0.00015999518, 0.00036709806) (0.00016, 0.00036690182) (0.00016, 0.00020609818) (0.00015999518, 0.00020590194) (0.00015997111, 0.00020541201) (0.00015993266, 0.0002050216) (0.0001598751, 0.00020463354) (0.00015979856, 0.00020424877) (0.00015970324, 0.00020386823) (0.00015958936, 0.00020349281) (0.0001594572, 0.00020312344) (0.00015930707, 0.000202761) (0.00015913934, 0.00020240636) (0.00015895441, 0.00020206038) (0.00015875272, 0.00020172389) (0.00015853477, 0.0002013977) (0.00015830107, 0.0002010826) (0.0001580522, 0.00020077934) (0.00015778874, 0.00020048866) (0.00015751134, 0.00020021126) (0.00015722066, 0.0001999478) (0.0001569174, 0.00019969893) (0.0001566023, 0.00019946523) (0.00015627611, 0.00019924728) (0.00015593962, 0.00019904559) (0.00015559364, 0.00019886066) (0.000155239, 0.00019869293) (0.00015487656, 0.0001985428) (0.00015450719, 0.00019841064) (0.00015413177, 0.00019829676) (0.00015375123, 0.00019820144) (0.00015336646, 0.0001981249) (0.0001529784, 0.00019806734) (0.00015258799, 0.00019802889) (0.00015209806, 0.00019800482) (0.00015190182, 0.000198) (-0.00015190182, 0.000198) (-0.00015209806, 0.00019800482) (-0.00015258799, 0.00019802889) (-0.0001529784, 0.00019806734) (-0.00015336646, 0.0001981249) (-0.00015375123, 0.00019820144) (-0.00015413177, 0.00019829676) (-0.00015450719, 0.00019841064) (-0.00015487656, 0.0001985428) (-0.000155239, 0.00019869293) (-0.00015559364, 0.00019886066) (-0.00015593962, 0.00019904559) (-0.00015627611, 0.00019924728) (-0.0001566023, 0.00019946523) (-0.0001569174, 0.00019969893) (-0.00015722066, 0.0001999478) (-0.00015751134, 0.00020021126) (-0.00015778874, 0.00020048866) (-0.0001580522, 0.00020077934) (-0.00015830107, 0.0002010826) (-0.00015853477, 0.0002013977) (-0.00015875272, 0.00020172389) (-0.00015895441, 0.00020206038) (-0.00015913934, 0.00020240636) (-0.00015930707, 0.000202761) (-0.0001594572, 0.00020312344) (-0.00015958936, 0.00020349281) (-0.00015970324, 0.00020386823) (-0.00015979856, 0.00020424877) (-0.0001598751, 0.00020463354) (-0.00015993266, 0.0002050216) (-0.00015997111, 0.00020541201) (-0.00015999518, 0.00020590194) (-0.00016, 0.00020609818) (-0.00016, 0.00036690182) (-0.00015999518, 0.00036709806) (-0.00015997111, 0.00036758799) (-0.00015993266, 0.0003679784) (-0.0001598751, 0.00036836646) (-0.00015979856, 0.00036875123) (-0.00015970324, 0.00036913177) (-0.00015958936, 0.00036950719) (-0.0001594572, 0.00036987656) (-0.00015930707, 0.000370239) (-0.00015913934, 0.00037059364) (-0.00015895441, 0.00037093962) (-0.00015875272, 0.00037127611) (-0.00015853477, 0.0003716023) (-0.00015830107, 0.0003719174) (-0.0001580522, 0.00037222066) (-0.00015778874, 0.00037251134) (-0.00015751134, 0.00037278874) (-0.00015722066, 0.0003730522) (-0.0001569174, 0.00037330107) (-0.0001566023, 0.00037353477) (-0.00015627611, 0.00037375272) (-0.00015593962, 0.00037395441) (-0.00015559364, 0.00037413934) (-0.000155239, 0.00037430707) (-0.00015487656, 0.0003744572) (-0.00015450719, 0.00037458936) (-0.00015413177, 0.00037470324) (-0.00015375123, 0.00037479856) (-0.00015336646, 0.0003748751) (-0.0001529784, 0.00037493266) (-0.00015258799, 0.00037497111) (-0.00015209806, 0.00037499518) (-0.00015190182, 0.000375) (-2.509818e-05, 0.000375) (-2.4901939e-05, 0.00037499518) (-2.4412015e-05, 0.00037497111) (-2.40216e-05, 0.00037493266) (-2.3633541e-05, 0.0003748751) (-2.3248774e-05, 0.00037479856) (-2.2868226e-05, 0.00037470324) (-2.2492814e-05, 0.00037458936) (-2.2123441e-05, 0.0003744572) (-2.1760999e-05, 0.00037430707) (-2.140636e-05, 0.00037413934) (-2.1060378e-05, 0.00037395441) (-2.0723887e-05, 0.00037375272) (-2.0397697e-05, 0.00037353477) (-2.0082595e-05, 0.00037330107) (-1.9779339e-05, 0.0003730522) (-1.948866e-05, 0.00037278874) (-1.9211259e-05, 0.00037251134) (-1.8947803e-05, 0.00037222066) (-1.8698928e-05, 0.0003719174) (-1.8465232e-05, 0.0003716023) (-1.8247279e-05, 0.00037127611) (-1.8045594e-05, 0.00037093962) (-1.7860663e-05, 0.00037059364) (-1.7692931e-05, 0.000370239) (-1.7542802e-05, 0.00036987656) (-1.7410639e-05, 0.00036950719) (-1.7296759e-05, 0.00036913177) (-1.7201436e-05, 0.00036875123) (-1.7124902e-05, 0.00036836646) (-1.7067338e-05, 0.0003679784) (-1.7028886e-05, 0.00036758799) (-1.7004817e-05, 0.00036709806) (-1.7e-05, 0.00036690182) (-1.7e-05, 0.00032309818) (-1.7004817e-05, 0.00032290194) (-1.7028886e-05, 0.00032241201) (-1.7067338e-05, 0.0003220216) (-1.7124902e-05, 0.00032163354) (-1.7201436e-05, 0.00032124877) (-1.7296759e-05, 0.00032086823) (-1.7410639e-05, 0.00032049281) (-1.7542802e-05, 0.00032012344) (-1.7692931e-05, 0.000319761) (-1.7860663e-05, 0.00031940636) (-1.8045594e-05, 0.00031906038) (-1.8247279e-05, 0.00031872389) (-1.8465232e-05, 0.0003183977) (-1.8698928e-05, 0.00031808259) (-1.8947803e-05, 0.00031777934) (-1.9211259e-05, 0.00031748866) (-1.948866e-05, 0.00031721126) (-1.9779339e-05, 0.0003169478) (-2.0082595e-05, 0.00031669893) (-2.0397697e-05, 0.00031646523) (-2.0723887e-05, 0.00031624728) (-2.1060378e-05, 0.00031604559) (-2.140636e-05, 0.00031586066) (-2.1760999e-05, 0.00031569293) (-2.2123441e-05, 0.0003155428) (-2.2492814e-05, 0.00031541064) (-2.2868226e-05, 0.00031529676)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, closed, covered)
  pocket_cp = polyline(z=0, xy: (0.00016, 0.000186) (-0.00016, 0.000186) (-0.00016117621, 0.00018605778) (-0.00016234108, 0.00018623058) (-0.00016348342, 0.00018651672) (-0.0001645922, 0.00018691345) (-0.00016565676, 0.00018741695) (-0.00016666684, 0.00018802236) (-0.00016761272, 0.00018872387) (-0.00016848528, 0.00018951472) (-0.00016927613, 0.00019038728) (-0.00016997764, 0.00019133316) (-0.00017058306, 0.00019234324) (-0.00017108655, 0.0001934078) (-0.00017148328, 0.00019451658) (-0.00017176942, 0.00019565892) (-0.00017194222, 0.00019682379) (-0.000172, 0.000198) (-0.000172, 0.000375) (-0.00017194222, 0.00037617621) (-0.00017176942, 0.00037734108) (-0.00017148328, 0.00037848342) (-0.00017108655, 0.0003795922) (-0.00017058306, 0.00038065676) (-0.00016997764, 0.00038166684) (-0.00016927613, 0.00038261272) (-0.00016848528, 0.00038348528) (-0.00016761272, 0.00038427613) (-0.00016666684, 0.00038497764) (-0.00016565676, 0.00038558305) (-0.0001645922, 0.00038608655) (-0.00016348342, 0.00038648328) (-0.00016234108, 0.00038676942) (-0.00016117621, 0.00038694222) (-0.00016, 0.000387) (0.00016, 0.000387) (0.00016117621, 0.00038694222) (0.00016234108, 0.00038676942) (0.00016348342, 0.00038648328) (0.0001645922, 0.00038608655) (0.00016565676, 0.00038558305) (0.00016666684, 0.00038497764) (0.00016761272, 0.00038427613) (0.00016848528, 0.00038348528) (0.00016927613, 0.00038261272) (0.00016997764, 0.00038166684) (0.00017058306, 0.00038065676) (0.00017108655, 0.0003795922) (0.00017148328, 0.00037848342) (0.00017176942, 0.00037734108) (0.00017194222, 0.00037617621) (0.000172, 0.000375) (0.000172, 0.000198) (0.00017194222, 0.00019682379) (0.00017176942, 0.00019565892) (0.00017148328, 0.00019451658) (0.00017108655, 0.0001934078) (0.00017058306, 0.00019234324) (0.00016997764, 0.00019133316) (0.00016927613, 0.00019038728) (0.00016848528, 0.00018951472) (0.00016761272, 0.00018872387) (0.00016666684, 0.00018802236) (0.00016565676, 0.00018741695) (0.0001645922, 0.00018691345) (0.00016348342, 0.00018651672) (0.00016234108, 0.00018623058) (0.00016117621, 0.00018605778) (0.00016, 0.000186), closed, covered)
  tap_trace_jf [copper] = polyline(z=0, xy: (-8e-06, 0.001465) (-8e-06, 0.001765) (8e-06, 0.001765) (8e-06, 0.001623) (0.000124, 0.001623) (0.000124, 0.001607) (8e-06, 0.001607) (8e-06, 0.001465) (-8e-06, 0.001465), closed, covered)
  tap_cut_jf = polyline(z=0, xy: (-1.7e-05, 0.001465) (-1.7e-05, 0.001765) (1.7e-05, 0.001765) (1.7e-05, 0.001632) (0.000124, 0.001632) (0.000124, 0.001598) (1.7e-05, 0.001598) (1.7e-05, 0.001465) (-1.7e-05, 0.001465), closed, covered)
  tap_trace_jr [copper] = polyline(z=0, xy: (0.000276, 0.001623) (0.000392, 0.001623) (0.000392, 0.001765) (0.000408, 0.001765) (0.000408, 0.001465) (0.000392, 0.001465) (0.000392, 0.001607) (0.000276, 0.001607) (0.000276, 0.001623), closed, covered)
  tap_cut_jr = polyline(z=0, xy: (0.000276, 0.001632) (0.000383, 0.001632) (0.000383, 0.001765) (0.000417, 0.001765) (0.000417, 0.001465) (0.000383, 0.001465) (0.000383, 0.001598) (0.000276, 0.001598) (0.000276, 0.001632), closed, covered)
  head_a_cj [copper] = polyline(z=0, xy: (0.000156, 0.0015825) (0.00015580397, 0.0015825096) (0.00015560982, 0.0015825384) (0.00015541943, 0.0015825861) (0.00015523463, 0.0015826522) (0.00015505721, 0.0015827362) (0.00015488886, 0.0015828371) (0.00015473121, 0.001582954) (0.00015458579, 0.0015830858) (0.00015445398, 0.0015832312) (0.00015433706, 0.0015833889) (0.00015423616, 0.0015835572) (0.00015415224, 0.0015837346) (0.00015408612, 0.0015839194) (0.00015403843, 0.0015841098) (0.00015400963, 0.001584304) (0.000154, 0.0015845) (0.000154, 0.0016455) (0.00015400963, 0.001645696) (0.00015403843, 0.0016458902) (0.00015408612, 0.0016460806) (0.00015415224, 0.0016462654) (0.00015423616, 0.0016464428) (0.00015433706, 0.0016466111) (0.00015445398, 0.0016467688) (0.00015458579, 0.0016469142) (0.00015473121, 0.001647046) (0.00015488886, 0.0016471629) (0.00015505721, 0.0016472638) (0.00015523463, 0.0016473478) (0.00015541943, 0.0016474139) (0.00015560982, 0.0016474616) (0.00015580397, 0.0016474904) (0.000156, 0.0016475) (0.000177, 0.0016475) (0.00017719603, 0.0016474904) (0.00017739018, 0.0016474616) (0.00017758057, 0.0016474139) (0.00017776537, 0.0016473478) (0.00017794279, 0.0016472638) (0.00017811114, 0.0016471629) (0.00017826879, 0.001647046) (0.00017841421, 0.0016469142) (0.00017854602, 0.0016467688) (0.00017866294, 0.0016466111) (0.00017876384, 0.0016464428) (0.00017884776, 0.0016462654) (0.00017891388, 0.0016460806) (0.00017896157, 0.0016458902) (0.00017899037, 0.001645696) (0.000179, 0.0016455) (0.000179, 0.0015845) (0.00017899037, 0.001584304) (0.00017896157, 0.0015841098) (0.00017891388, 0.0015839194) (0.00017884776, 0.0015837346) (0.00017876384, 0.0015835572) (0.00017866294, 0.0015833889) (0.00017854602, 0.0015832312) (0.00017841421, 0.0015830858) (0.00017826879, 0.001582954) (0.00017811114, 0.0015828371) (0.00017794279, 0.0015827362) (0.00017776537, 0.0015826522) (0.00017758057, 0.0015825861) (0.00017739018, 0.0015825384) (0.00017719603, 0.0015825096) (0.000177, 0.0015825) (0.000156, 0.0015825), closed, covered)
  head_b_cj [copper] = polyline(z=0, xy: (0.000223, 0.0015825) (0.00022280397, 0.0015825096) (0.00022260982, 0.0015825384) (0.00022241943, 0.0015825861) (0.00022223463, 0.0015826522) (0.00022205721, 0.0015827362) (0.00022188886, 0.0015828371) (0.00022173121, 0.001582954) (0.00022158579, 0.0015830858) (0.00022145398, 0.0015832312) (0.00022133706, 0.0015833889) (0.00022123616, 0.0015835572) (0.00022115224, 0.0015837346) (0.00022108612, 0.0015839194) (0.00022103843, 0.0015841098) (0.00022100963, 0.001584304) (0.000221, 0.0015845) (0.000221, 0.0016455) (0.00022100963, 0.001645696) (0.00022103843, 0.0016458902) (0.00022108612, 0.0016460806) (0.00022115224, 0.0016462654) (0.00022123616, 0.0016464428) (0.00022133706, 0.0016466111) (0.00022145398, 0.0016467688) (0.00022158579, 0.0016469142) (0.00022173121, 0.001647046) (0.00022188886, 0.0016471629) (0.00022205721, 0.0016472638) (0.00022223463, 0.0016473478) (0.00022241943, 0.0016474139) (0.00022260982, 0.0016474616) (0.00022280397, 0.0016474904) (0.000223, 0.0016475) (0.000244, 0.0016475) (0.00024419603, 0.0016474904) (0.00024439018, 0.0016474616) (0.00024458057, 0.0016474139) (0.00024476537, 0.0016473478) (0.00024494279, 0.0016472638) (0.00024511114, 0.0016471629) (0.00024526879, 0.001647046) (0.00024541421, 0.0016469142) (0.00024554602, 0.0016467688) (0.00024566294, 0.0016466111) (0.00024576384, 0.0016464428) (0.00024584776, 0.0016462654) (0.00024591388, 0.0016460806) (0.00024596157, 0.0016458902) (0.00024599037, 0.001645696) (0.000246, 0.0016455) (0.000246, 0.0015845) (0.00024599037, 0.001584304) (0.00024596157, 0.0015841098) (0.00024591388, 0.0015839194) (0.00024584776, 0.0015837346) (0.00024576384, 0.0015835572) (0.00024566294, 0.0015833889) (0.00024554602, 0.0015832312) (0.00024541421, 0.0015830858) (0.00024526879, 0.001582954) (0.00024511114, 0.0015828371) (0.00024494279, 0.0015827362) (0.00024476537, 0.0015826522) (0.00024458057, 0.0015825861) (0.00024439018, 0.0015825384) (0.00024419603, 0.0015825096) (0.000244, 0.0015825) (0.000223, 0.0015825), closed, covered)
  pocket_cj = polyline(z=0, xy: (0.00014, 0.0015665) (0.00013980397, 0.0015665096) (0.00013960982, 0.0015665384) (0.00013941943, 0.0015665861) (0.00013923463, 0.0015666522) (0.00013905721, 0.0015667362) (0.00013888886, 0.0015668371) (0.00013873121, 0.001566954) (0.00013858579, 0.0015670858) (0.00013845398, 0.0015672312) (0.00013833706, 0.0015673889) (0.00013823616, 0.0015675572) (0.00013815224, 0.0015677346) (0.00013808612, 0.0015679194) (0.00013803843, 0.0015681098) (0.00013800963, 0.001568304) (0.000138, 0.0015685) (0.000138, 0.0016615) (0.00013800963, 0.001661696) (0.00013803843, 0.0016618902) (0.00013808612, 0.0016620806) (0.00013815224, 0.0016622654) (0.00013823616, 0.0016624428) (0.00013833706, 0.0016626111) (0.00013845398, 0.0016627688) (0.00013858579, 0.0016629142) (0.00013873121, 0.001663046) (0.00013888886, 0.0016631629) (0.00013905721, 0.0016632638) (0.00013923463, 0.0016633478) (0.00013941943, 0.0016634139) (0.00013960982, 0.0016634616) (0.00013980397, 0.0016634904) (0.00014, 0.0016635) (0.00026, 0.0016635) (0.00026019603, 0.0016634904) (0.00026039018, 0.0016634616) (0.00026058057, 0.0016634139) (0.00026076537, 0.0016633478) (0.00026094279, 0.0016632638) (0.00026111114, 0.0016631629) (0.00026126879, 0.001663046) (0.00026141421, 0.0016629142) (0.00026154602, 0.0016627688) (0.00026166294, 0.0016626111) (0.00026176384, 0.0016624428) (0.00026184776, 0.0016622654) (0.00026191388, 0.0016620806) (0.00026196157, 0.0016618902) (0.00026199037, 0.001661696) (0.000262, 0.0016615) (0.000262, 0.0015685) (0.00026199037, 0.001568304) (0.00026196157, 0.0015681098) (0.00026191388, 0.0015679194) (0.00026184776, 0.0015677346) (0.00026176384, 0.0015675572) (0.00026166294, 0.0015673889) (0.00026154602, 0.0015672312) (0.00026141421, 0.0015670858) (0.00026126879, 0.001566954) (0.00026111114, 0.0015668371) (0.00026094279, 0.0015667362) (0.00026076537, 0.0015666522) (0.00026058057, 0.0015665861) (0.00026039018, 0.0015665384) (0.00026019603, 0.0015665096) (0.00026, 0.0015665) (0.00014, 0.0015665), closed, covered)
  open_to_ground_readout_open = rectangle(corner=(0.000383, 0.002915, 0), x_size=3.4e-05, y_size=6e-06)
  endcap_filter_tail_end = rectangle(corner=(-0.0008146, 0.0012909213, 0), x_size=2.92e-05, y_size=9.6e-06)
  endcap_res_tail_end = rectangle(corner=(0.0007854, 0.0029225638, 0), x_size=2.92e-05, y_size=9.6e-06)
  ground_main_plane [copper] = rectangle(corner=(-0.0022485, -0.0003765, 0), x_size=0.004497, y_size=0.0034990638)
  main [silicon_eps11p5] = box(corner=(-0.0022485, -0.0003765, -0.0005), size=(0.004497, 0.0034990638, 0.0005))
  ground_main_plane.subtract(pocket_LPPin, tap_cut_jf, lead_a_sub_cin, open_to_ground_readout_open, endcap_filter_tail_end, cut_feed_jf, cut_feed_mid, cut_stub_p, cut_res_tail, pocket_LPPout, lead_b_sub_cj, cut_res_open_run, lead_b_sub_cp, tap_cut_n0, pocket_cin, endcap_res_tail_end, tap_cut_jr, lead_a_sub_cj, cut_feed_out, cut_stub_r, cut_filter_tail, cut_stub_f, lead_b_sub_cin, cut_feed_in, lead_a_sub_cp, pocket_cp, pocket_cj)
boundaries and excitations:
  ThinCond1: ThinConductor Objects=[lead_a_cin, lead_b_cin, lead_a_cp, lead_b_cp, trace_feed_in, trace_feed_mid, trace_feed_out, trace_stub_p, lead_a_cj, lead_b_cj, trace_stub_f, trace_stub_r, trace_feed_jf, trace_res_open_run, trace_filter_tail, trace_res_tail, launch_pad_LPPin, launch_pad_LPPout, plate_cin, frame_cin, tap_trace_n0, plate_cp, frame_cp, tap_trace_jf, tap_trace_jr, head_a_cj, head_b_cj, ground_main_plane] Material=pec Thickness=200nm
  frame_cin: SignalNet Objects=[lead_a_cin, trace_feed_in, launch_pad_LPPin, frame_cin]
  frame_cp: SignalNet Objects=[lead_b_cin, lead_a_cp, trace_feed_mid, trace_feed_out, trace_stub_p, launch_pad_LPPout, plate_cin, tap_trace_n0, frame_cp]
  head_a_cj: SignalNet Objects=[lead_b_cp, lead_a_cj, trace_stub_f, trace_feed_jf, trace_filter_tail, plate_cp, tap_trace_jf, head_a_cj]
  head_b_cj: SignalNet Objects=[lead_b_cj, trace_stub_r, trace_res_open_run, trace_res_tail, tap_trace_jr, head_b_cj]
  g_wb: SignalNet Objects=[g_wb, g_wb_1..g_wb_29, ground_main_plane]
setups:
  Setup: Matrix AdaptiveFreq=6.5GHz Cap{MaxPass=8 MinPass=2 MinConvPass=2 PerError=0.3 PerRefine=30 AutoIncreaseSolutionOrder SolutionOrder=Normal Solver_Type=Iterative}
source amplitudes:
  frame_cin: Cap 1V 0deg
  frame_cp, g_wb, head_a_cj, head_b_cj: Cap 0V 0deg

design W400g42_s21_p0um_1656_hfss (HFSS, DrivenModal, model units mm)
geometry:
  lead_a_cin_path = polyline((-0.000744499, 0, 0) (-0.0007925, 0, 0))
  lead_a_cin = polyline((-0.000744499, -8e-06, 0) (-0.000744499, 8e-06, 0))
  lead_a_cin.sweep_along_path(lead_a_cin_path)
  lead_a_sub_cin_path = polyline((-0.000744499, 0, 0) (-0.0007925, 0, 0))
  lead_a_sub_cin = polyline((-0.000744499, -1.7e-05, 0) (-0.000744499, 1.7e-05, 0))
  lead_a_sub_cin.sweep_along_path(lead_a_sub_cin_path)
  lead_b_cin_path = polyline((-0.000639501, 0, 0) (-0.0005275, 0, 0))
  lead_b_cin = polyline((-0.000639501, 8e-06, 0) (-0.000639501, -8e-06, 0))
  lead_b_cin.sweep_along_path(lead_b_cin_path)
  lead_b_sub_cin_path = polyline((-0.000639501, 0, 0) (-0.0005275, 0, 0))
  lead_b_sub_cin = polyline((-0.000639501, 1.7e-05, 0) (-0.000639501, -1.7e-05, 0))
  lead_b_sub_cin.sweep_along_path(lead_b_sub_cin_path)
  lead_a_cp_path = polyline((0, 0.000198001, 0) (0, 0.00015, 0))
  lead_a_cp = polyline((8e-06, 0.000198001, 0) (-8e-06, 0.000198001, 0))
  lead_a_cp.sweep_along_path(lead_a_cp_path)
  lead_a_sub_cp_path = polyline((0, 0.000198001, 0) (0, 0.00015, 0))
  lead_a_sub_cp = polyline((1.7e-05, 0.000198001, 0) (-1.7e-05, 0.000198001, 0))
  lead_a_sub_cp.sweep_along_path(lead_a_sub_cp_path)
  lead_b_cp_path = polyline((0, 0.000302999, 0) (0, 0.000415, 0))
  lead_b_cp = polyline((-8e-06, 0.000302999, 0) (8e-06, 0.000302999, 0))
  lead_b_cp.sweep_along_path(lead_b_cp_path)
  lead_b_sub_cp_path = polyline((0, 0.000302999, 0) (0, 0.000415, 0))
  lead_b_sub_cp = polyline((-1.7e-05, 0.000302999, 0) (1.7e-05, 0.000302999, 0))
  lead_b_sub_cp.sweep_along_path(lead_b_sub_cp_path)
  trace_feed_in_path = polyline((-0.00162, 0, 0) (-0.0007925, 0, 0))
  trace_feed_in = polyline((-0.00162, 8e-06, 0) (-0.00162, -8e-06, 0))
  trace_feed_in.sweep_along_path(trace_feed_in_path)
  cut_feed_in_path = polyline((-0.00162, 0, 0) (-0.0007925, 0, 0))
  cut_feed_in = polyline((-0.00162, 1.7e-05, 0) (-0.00162, -1.7e-05, 0))
  cut_feed_in.sweep_along_path(cut_feed_in_path)
  trace_feed_mid_path = polyline((-0.0005275, 0, 0) (-0.00015, 0, 0))
  trace_feed_mid = polyline((-0.0005275, 8e-06, 0) (-0.0005275, -8e-06, 0))
  trace_feed_mid.sweep_along_path(trace_feed_mid_path)
  cut_feed_mid_path = polyline((-0.0005275, 0, 0) (-0.00015, 0, 0))
  cut_feed_mid = polyline((-0.0005275, 1.7e-05, 0) (-0.0005275, -1.7e-05, 0))
  cut_feed_mid.sweep_along_path(cut_feed_mid_path)
  trace_feed_out_path = polyline((0.00015, 0, 0) (0.00162, 0, 0))
  trace_feed_out = polyline((0.00015, 8e-06, 0) (0.00015, -8e-06, 0))
  trace_feed_out.sweep_along_path(trace_feed_out_path)
  cut_feed_out_path = polyline((0.00015, 0, 0) (0.00162, 0, 0))
  cut_feed_out = polyline((0.00015, 1.7e-05, 0) (0.00015, -1.7e-05, 0))
  cut_feed_out.sweep_along_path(cut_feed_out_path)
  trace_stub_p_path = polyline((0, 0.0001, 0) (0, 0.00015, 0))
  trace_stub_p = polyline((-8e-06, 0.0001, 0) (8e-06, 0.0001, 0))
  trace_stub_p.sweep_along_path(trace_stub_p_path)
  cut_stub_p_path = polyline((0, 0.0001, 0) (0, 0.00015, 0))
  cut_stub_p = polyline((-1.7e-05, 0.0001, 0) (1.7e-05, 0.0001, 0))
  cut_stub_p.sweep_along_path(cut_stub_p_path)
  lead_a_cj_path = polyline((0.000154001, 0.001615, 0) (0.000144, 0.001615, 0))
  lead_a_cj = polyline((0.000154001, 0.001607, 0) (0.000154001, 0.001623, 0))
  lead_a_cj.sweep_along_path(lead_a_cj_path)
  lead_a_sub_cj_path = polyline((0.000154001, 0.001615, 0) (0.000144, 0.001615, 0))
  lead_a_sub_cj = polyline((0.000154001, 0.001598, 0) (0.000154001, 0.001632, 0))
  lead_a_sub_cj.sweep_along_path(lead_a_sub_cj_path)
  lead_b_cj_path = polyline((0.000245999, 0.001615, 0) (0.000256, 0.001615, 0))
  lead_b_cj = polyline((0.000245999, 0.001623, 0) (0.000245999, 0.001607, 0))
  lead_b_cj.sweep_along_path(lead_b_cj_path)
  lead_b_sub_cj_path = polyline((0.000245999, 0.001615, 0) (0.000256, 0.001615, 0))
  lead_b_sub_cj = polyline((0.000245999, 0.001632, 0) (0.000245999, 0.001598, 0))
  lead_b_sub_cj.sweep_along_path(lead_b_sub_cj_path)
  trace_stub_f_path = polyline((0.000124, 0.001615, 0) (0.000144, 0.001615, 0))
  trace_stub_f = polyline((0.000124, 0.001623, 0) (0.000124, 0.001607, 0))
  trace_stub_f.sweep_along_path(trace_stub_f_path)
  cut_stub_f_path = polyline((0.000124, 0.001615, 0) (0.000144, 0.001615, 0))
  cut_stub_f = polyline((0.000124, 0.001632, 0) (0.000124, 0.001598, 0))
  cut_stub_f.sweep_along_path(cut_stub_f_path)
  trace_stub_r_path = polyline((0.000256, 0.001615, 0) (0.000276, 0.001615, 0))
  trace_stub_r = polyline((0.000256, 0.001623, 0) (0.000256, 0.001607, 0))
  trace_stub_r.sweep_along_path(trace_stub_r_path)
  cut_stub_r_path = polyline((0.000256, 0.001615, 0) (0.000276, 0.001615, 0))
  cut_stub_r = polyline((0.000256, 0.001632, 0) (0.000256, 0.001598, 0))
  cut_stub_r.sweep_along_path(cut_stub_r_path)
  trace_feed_jf_path = polyline((0, 0.000415, 0) (0, 0.001465, 0))
  trace_feed_jf = polyline((-8e-06, 0.000415, 0) (8e-06, 0.000415, 0))
  trace_feed_jf.sweep_along_path(trace_feed_jf_path)
  cut_feed_jf_path = polyline((0, 0.000415, 0) (0, 0.001465, 0))
  cut_feed_jf = polyline((-1.7e-05, 0.000415, 0) (1.7e-05, 0.000415, 0))
  cut_feed_jf.sweep_along_path(cut_feed_jf_path)
  trace_res_open_run_path = polyline((0.0004, 0.001765, 0) (0.0004, 0.002915, 0))
  trace_res_open_run = polyline((0.000392, 0.001765, 0) (0.000408, 0.001765, 0))
  trace_res_open_run.sweep_along_path(trace_res_open_run_path)
  cut_res_open_run_path = polyline((0.0004, 0.001765, 0) (0.0004, 0.002915, 0))
  cut_res_open_run = polyline((0.000383, 0.001765, 0) (0.000417, 0.001765, 0))
  cut_res_open_run.sweep_along_path(cut_res_open_run_path)
  trace_filter_tail_path = polyline(z=0, xy: (0, 0.001765) (0, 0.002165) (-0.0004, 0.002165) (-0.0004, 0.00065) (-0.0008, 0.00065) (-0.0008, 0.0012909213))
  trace_filter_tail_path.fillet(Vertices=trace_filter_tail_path.vertex(2 of 6, 3 of 6, 4 of 6, 5 of 6) Radius=9.9e-05 Setback=0mm)
  trace_filter_tail = polyline((-8e-06, 0.001765, 0) (8e-06, 0.001765, 0))
  trace_filter_tail.sweep_along_path(trace_filter_tail_path)
  cut_filter_tail_path = polyline(z=0, xy: (0, 0.001765) (0, 0.002165) (-0.0004, 0.002165) (-0.0004, 0.00065) (-0.0008, 0.00065) (-0.0008, 0.0012909213))
  cut_filter_tail_path.fillet(Vertices=cut_filter_tail_path.vertex(2 of 6, 3 of 6, 4 of 6, 5 of 6) Radius=9.9e-05 Setback=0mm)
  cut_filter_tail = polyline((-1.7e-05, 0.001765, 0) (1.7e-05, 0.001765, 0))
  cut_filter_tail.sweep_along_path(cut_filter_tail_path)
  trace_res_tail_path = polyline(z=0, xy: (0.0004, 0.001465) (0.0004, 0.00065) (0.0008, 0.00065) (0.0008, 0.0029225638))
  trace_res_tail_path.fillet(Vertices=trace_res_tail_path.vertex(2 of 4, 3 of 4) Radius=9.9e-05 Setback=0mm)
  trace_res_tail = polyline((0.000408, 0.001465, 0) (0.000392, 0.001465, 0))
  trace_res_tail.sweep_along_path(trace_res_tail_path)
  cut_res_tail_path = polyline(z=0, xy: (0.0004, 0.001465) (0.0004, 0.00065) (0.0008, 0.00065) (0.0008, 0.0029225638))
  cut_res_tail_path.fillet(Vertices=cut_res_tail_path.vertex(2 of 4, 3 of 4) Radius=9.9e-05 Setback=0mm)
  cut_res_tail = polyline((0.000417, 0.001465, 0) (0.000383, 0.001465, 0))
  cut_res_tail.sweep_along_path(cut_res_tail_path)
  g_wb [pec] = bondwire(WireType=LOW WireDiameter=0.015mm NumSides=6 XPadPos=-0.0013441667 YPadPos=-3.4e-05 ZPadPos=0 XDir=0 YDir=1 ZDir=0 Distance=6.8e-05 h1=6.8e-05 h2=0mm alpha=80deg beta=80deg WhichAxis=Z)
  g_wb_1 [pec] = bondwire(WireType=LOW WireDiameter=0.015mm NumSides=6 XPadPos=-0.0010683333 YPadPos=-3.4e-05 ZPadPos=0 XDir=0 YDir=1 ZDir=0 Distance=6.8e-05 h1=6.8e-05 h2=0mm alpha=80deg beta=80deg WhichAxis=Z)
  g_wb_2 [pec] = bondwire(WireType=LOW WireDiameter=0.015mm NumSides=6 XPadPos=-0.00033875 YPadPos=-3.4e-05 ZPadPos=0 XDir=0 YDir=1 ZDir=0 Distance=6.8e-05 h1=6.8e-05 h2=0mm alpha=80deg beta=80deg WhichAxis=Z)
  g_wb_3 [pec] = bondwire(WireType=LOW WireDiameter=0.015mm NumSides=6 XPadPos=0.000444 YPadPos=-3.4e-05 ZPadPos=0 XDir=0 YDir=1 ZDir=0 Distance=6.8e-05 h1=6.8e-05 h2=0mm alpha=80deg beta=80deg WhichAxis=Z)
  g_wb_4 [pec] = bondwire(WireType=LOW WireDiameter=0.015mm NumSides=6 XPadPos=0.000738 YPadPos=-3.4e-05 ZPadPos=0 XDir=0 YDir=1 ZDir=0 Distance=6.8e-05 h1=6.8e-05 h2=0mm alpha=80deg beta=80deg WhichAxis=Z)
  g_wb_5 [pec] = bondwire(WireType=LOW WireDiameter=0.015mm NumSides=6 XPadPos=0.001032 YPadPos=-3.4e-05 ZPadPos=0 XDir=0 YDir=1 ZDir=0 Distance=6.8e-05 h1=6.8e-05 h2=0mm alpha=80deg beta=80deg WhichAxis=Z)
  g_wb_6 [pec] = bondwire(WireType=LOW WireDiameter=0.015mm NumSides=6 XPadPos=0.001326 YPadPos=-3.4e-05 ZPadPos=0 XDir=0 YDir=1 ZDir=0 Distance=6.8e-05 h1=6.8e-05 h2=0mm alpha=80deg beta=80deg WhichAxis=Z)
  g_wb_7 [pec] = bondwire(WireType=LOW WireDiameter=0.015mm NumSides=6 XPadPos=3.4e-05 YPadPos=0.0006775 ZPadPos=0 XDir=-1 YDir=0 ZDir=0 Distance=6.8e-05 h1=6.8e-05 h2=0mm alpha=80deg beta=80deg WhichAxis=Z)
  g_wb_8 [pec] = bondwire(WireType=LOW WireDiameter=0.015mm NumSides=6 XPadPos=3.4e-05 YPadPos=0.00094 ZPadPos=0 XDir=-1 YDir=0 ZDir=0 Distance=6.8e-05 h1=6.8e-05 h2=0mm alpha=80deg beta=80deg WhichAxis=Z)
  g_wb_9 [pec] = bondwire(WireType=LOW WireDiameter=0.015mm NumSides=6 XPadPos=3.4e-05 YPadPos=0.0012025 ZPadPos=0 XDir=-1 YDir=0 ZDir=0 Distance=6.8e-05 h1=6.8e-05 h2=0mm alpha=80deg beta=80deg WhichAxis=Z)
  g_wb_10 [pec] = bondwire(WireType=LOW WireDiameter=0.015mm NumSides=6 XPadPos=0.000434 YPadPos=0.0020525 ZPadPos=0 XDir=-1 YDir=0 ZDir=0 Distance=6.8e-05 h1=6.8e-05 h2=0mm alpha=80deg beta=80deg WhichAxis=Z)
  g_wb_11 [pec] = bondwire(WireType=LOW WireDiameter=0.015mm NumSides=6 XPadPos=0.000434 YPadPos=0.00234 ZPadPos=0 XDir=-1 YDir=0 ZDir=0 Distance=6.8e-05 h1=6.8e-05 h2=0mm alpha=80deg beta=80deg WhichAxis=Z)
  g_wb_12 [pec] = bondwire(WireType=LOW WireDiameter=0.015mm NumSides=6 XPadPos=0.000434 YPadPos=0.0026275 ZPadPos=0 XDir=-1 YDir=0 ZDir=0 Distance=6.8e-05 h1=6.8e-05 h2=0mm alpha=80deg beta=80deg WhichAxis=Z)
  g_wb_13 [pec] = bondwire(WireType=LOW WireDiameter=0.015mm NumSides=6 XPadPos=3.4e-05 YPadPos=0.001965 ZPadPos=0 XDir=-1 YDir=0 ZDir=0 Distance=6.8e-05 h1=6.8e-05 h2=0mm alpha=80deg beta=80deg WhichAxis=Z)
  g_wb_14 [pec] = bondwire(WireType=LOW WireDiameter=0.015mm NumSides=6 XPadPos=-0.0002 YPadPos=0.002199 ZPadPos=0 XDir=0 YDir=-1 ZDir=0 Distance=6.8e-05 h1=6.8e-05 h2=0mm alpha=80deg beta=80deg WhichAxis=Z)
  g_wb_15 [pec] = bondwire(WireType=LOW WireDiameter=0.015mm NumSides=6 XPadPos=-0.000434 YPadPos=0.001862 ZPadPos=0 XDir=1 YDir=0 ZDir=0 Distance=6.8e-05 h1=6.8e-05 h2=0mm alpha=80deg beta=80deg WhichAxis=Z)
  g_wb_16 [pec] = bondwire(WireType=LOW WireDiameter=0.015mm NumSides=6 XPadPos=-0.000434 YPadPos=0.001559 ZPadPos=0 XDir=1 YDir=0 ZDir=0 Distance=6.8e-05 h1=6.8e-05 h2=0mm alpha=80deg beta=80deg WhichAxis=Z)
  g_wb_17 [pec] = bondwire(WireType=LOW WireDiameter=0.015mm NumSides=6 XPadPos=-0.000434 YPadPos=0.001256 ZPadPos=0 XDir=1 YDir=0 ZDir=0 Distance=6.8e-05 h1=6.8e-05 h2=0mm alpha=80deg beta=80deg WhichAxis=Z)
  g_wb_18 [pec] = bondwire(WireType=LOW WireDiameter=0.015mm NumSides=6 XPadPos=-0.000434 YPadPos=0.000953 ZPadPos=0 XDir=1 YDir=0 ZDir=0 Distance=6.8e-05 h1=6.8e-05 h2=0mm alpha=80deg beta=80deg WhichAxis=Z)
  g_wb_19 [pec] = bondwire(WireType=LOW WireDiameter=0.015mm NumSides=6 XPadPos=-0.0006 YPadPos=0.000684 ZPadPos=0 XDir=0 YDir=-1 ZDir=0 Distance=6.8e-05 h1=6.8e-05 h2=0mm alpha=80deg beta=80deg WhichAxis=Z)
  g_wb_20 [pec] = bondwire(WireType=LOW WireDiameter=0.015mm NumSides=6 XPadPos=-0.000766 YPadPos=0.00097046066 ZPadPos=0 XDir=-1 YDir=0 ZDir=0 Distance=6.8e-05 h1=6.8e-05 h2=0mm alpha=80deg beta=80deg WhichAxis=Z)
  g_wb_21 [pec] = bondwire(WireType=LOW WireDiameter=0.015mm NumSides=6 XPadPos=0.000366 YPadPos=0.0011933333 ZPadPos=0 XDir=1 YDir=0 ZDir=0 Distance=6.8e-05 h1=6.8e-05 h2=0mm alpha=80deg beta=80deg WhichAxis=Z)
  g_wb_22 [pec] = bondwire(WireType=LOW WireDiameter=0.015mm NumSides=6 XPadPos=0.000366 YPadPos=0.00092166667 ZPadPos=0 XDir=1 YDir=0 ZDir=0 Distance=6.8e-05 h1=6.8e-05 h2=0mm alpha=80deg beta=80deg WhichAxis=Z)
  g_wb_23 [pec] = bondwire(WireType=LOW WireDiameter=0.015mm NumSides=6 XPadPos=0.0006 YPadPos=0.000616 ZPadPos=0 XDir=0 YDir=1 ZDir=0 Distance=6.8e-05 h1=6.8e-05 h2=0mm alpha=80deg beta=80deg WhichAxis=Z)
  g_wb_24 [pec] = bondwire(WireType=LOW WireDiameter=0.015mm NumSides=6 XPadPos=0.000834 YPadPos=0.00097465197 ZPadPos=0 XDir=-1 YDir=0 ZDir=0 Distance=6.8e-05 h1=6.8e-05 h2=0mm alpha=80deg beta=80deg WhichAxis=Z)
  g_wb_25 [pec] = bondwire(WireType=LOW WireDiameter=0.015mm NumSides=6 XPadPos=0.000834 YPadPos=0.0012993039 ZPadPos=0 XDir=-1 YDir=0 ZDir=0 Distance=6.8e-05 h1=6.8e-05 h2=0mm alpha=80deg beta=80deg WhichAxis=Z)
  g_wb_26 [pec] = bondwire(WireType=LOW WireDiameter=0.015mm NumSides=6 XPadPos=0.000834 YPadPos=0.0016239559 ZPadPos=0 XDir=-1 YDir=0 ZDir=0 Distance=6.8e-05 h1=6.8e-05 h2=0mm alpha=80deg beta=80deg WhichAxis=Z)
  g_wb_27 [pec] = bondwire(WireType=LOW WireDiameter=0.015mm NumSides=6 XPadPos=0.000834 YPadPos=0.0019486079 ZPadPos=0 XDir=-1 YDir=0 ZDir=0 Distance=6.8e-05 h1=6.8e-05 h2=0mm alpha=80deg beta=80deg WhichAxis=Z)
  g_wb_28 [pec] = bondwire(WireType=LOW WireDiameter=0.015mm NumSides=6 XPadPos=0.000834 YPadPos=0.0022732598 ZPadPos=0 XDir=-1 YDir=0 ZDir=0 Distance=6.8e-05 h1=6.8e-05 h2=0mm alpha=80deg beta=80deg WhichAxis=Z)
  g_wb_29 [pec] = bondwire(WireType=LOW WireDiameter=0.015mm NumSides=6 XPadPos=0.000834 YPadPos=0.0025979118 ZPadPos=0 XDir=-1 YDir=0 ZDir=0 Distance=6.8e-05 h1=6.8e-05 h2=0mm alpha=80deg beta=80deg WhichAxis=Z)
  plate_cin = polyline(z=0, xy: (-0.0006725, -9.1e-05) (-0.00067328414, -9.0961478e-05) (-0.00067406072, -9.0846282e-05) (-0.00067482228, -9.0655523e-05) (-0.00067556147, -9.0391036e-05) (-0.00067627117, -9.005537e-05) (-0.00067694456, -8.9651757e-05) (-0.00067757515, -8.9184084e-05) (-0.00067815685, -8.8656854e-05) (-0.00067868408, -8.8075146e-05) (-0.00067915176, -8.7444562e-05) (-0.00067955537, -8.6771174e-05) (-0.00067989104, -8.6061467e-05) (-0.00068015552, -8.5322277e-05) (-0.00068034628, -8.4560723e-05) (-0.00068046148, -8.3784137e-05) (-0.0006805, -8.3e-05) (-0.0006805, 8.3e-05) (-0.00068046148, 8.3784137e-05) (-0.00068034628, 8.4560723e-05) (-0.00068015552, 8.5322277e-05) (-0.00067989104, 8.6061467e-05) (-0.00067955537, 8.6771174e-05) (-0.00067915176, 8.7444562e-05) (-0.00067868408, 8.8075146e-05) (-0.00067815685, 8.8656854e-05) (-0.00067757515, 8.9184084e-05) (-0.00067694456, 8.9651757e-05) (-0.00067627117, 9.005537e-05) (-0.00067556147, 9.0391036e-05) (-0.00067482228, 9.0655523e-05) (-0.00067406072, 9.0846282e-05) (-0.00067328414, 9.0961478e-05) (-0.0006725, 9.1e-05) (-0.0006475, 9.1e-05) (-0.00064671586, 9.0961478e-05) (-0.00064593928, 9.0846282e-05) (-0.00064517772, 9.0655523e-05) (-0.00064443853, 9.0391036e-05) (-0.00064372883, 9.005537e-05) (-0.00064305544, 8.9651757e-05) (-0.00064242485, 8.9184084e-05) (-0.00064184315, 8.8656854e-05) (-0.00064131592, 8.8075146e-05) (-0.00064084824, 8.7444562e-05) (-0.00064044463, 8.6771174e-05) (-0.00064010896, 8.6061467e-05) (-0.00063984448, 8.5322277e-05) (-0.00063965372, 8.4560723e-05) (-0.00063953852, 8.3784137e-05) (-0.0006395, 8.3e-05) (-0.0006395, -8.3e-05) (-0.00063953852, -8.3784137e-05) (-0.00063965372, -8.4560723e-05) (-0.00063984448, -8.5322277e-05) (-0.00064010896, -8.6061467e-05) (-0.00064044463, -8.6771174e-05) (-0.00064084824, -8.7444562e-05) (-0.00064131592, -8.8075146e-05) (-0.00064184315, -8.8656854e-05) (-0.00064242485, -8.9184084e-05) (-0.00064305544, -8.9651757e-05) (-0.00064372883, -9.005537e-05) (-0.00064443853, -9.0391036e-05) (-0.00064517772, -9.0655523e-05) (-0.00064593928, -9.0846282e-05) (-0.00064671586, -9.0961478e-05) (-0.0006475, -9.1e-05) (-0.0006725, -9.1e-05), closed, covered)
  frame_cin = polyline(z=0, xy: (-0.0006925, -9.5e-05) (-0.00069246148, -9.5784137e-05) (-0.00069234628, -9.6560723e-05) (-0.00069215552, -9.7322277e-05) (-0.00069189104, -9.8061467e-05) (-0.00069155537, -9.8771174e-05) (-0.00069115176, -9.9444562e-05) (-0.00069068408, -0.00010007515) (-0.00069015685, -0.00010065685) (-0.00068957515, -0.00010118408) (-0.00068894456, -0.00010165176) (-0.00068827117, -0.00010205537) (-0.00068756147, -0.00010239104) (-0.00068682228, -0.00010265552) (-0.00068606072, -0.00010284628) (-0.00068528414, -0.00010296148) (-0.0006845, -0.000103) (-0.0006355, -0.000103) (-0.00063471586, -0.00010296148) (-0.00063393928, -0.00010284628) (-0.00063317772, -0.00010265552) (-0.00063243853, -0.00010239104) (-0.00063172883, -0.00010205537) (-0.00063105544, -0.00010165176) (-0.00063042485, -0.00010118408) (-0.00062984315, -0.00010065685) (-0.00062931592, -0.00010007515) (-0.00062884824, -9.9444562e-05) (-0.00062844463, -9.8771174e-05) (-0.00062810896, -9.8061467e-05) (-0.00062784448, -9.7322277e-05) (-0.00062765372, -9.6560723e-05) (-0.00062753852, -9.5784137e-05) (-0.0006275, -9.5e-05) (-0.0006275, -2.509818e-05) (-0.00062749518, -2.4901939e-05) (-0.00062747111, -2.4412015e-05) (-0.00062743266, -2.40216e-05) (-0.0006273751, -2.3633541e-05) (-0.00062729856, -2.3248774e-05) (-0.00062720324, -2.2868226e-05) (-0.00062708936, -2.2492814e-05) (-0.0006269572, -2.2123441e-05) (-0.00062680707, -2.1760999e-05) (-0.00062663934, -2.140636e-05) (-0.00062645441, -2.1060378e-05) (-0.00062625272, -2.0723887e-05) (-0.00062603477, -2.0397697e-05) (-0.00062580107, -2.0082595e-05) (-0.0006255522, -1.9779339e-05) (-0.00062528874, -1.948866e-05) (-0.00062501134, -1.9211259e-05) (-0.00062472066, -1.8947803e-05) (-0.0006244174, -1.8698928e-05) (-0.0006241023, -1.8465232e-05) (-0.00062377611, -1.8247279e-05) (-0.00062343962, -1.8045594e-05) (-0.00062309364, -1.7860663e-05) (-0.000622739, -1.7692931e-05) (-0.00062237656, -1.7542802e-05) (-0.00062200719, -1.7410639e-05) (-0.00062163177, -1.7296759e-05) (-0.00062125123, -1.7201436e-05) (-0.00062086646, -1.7124902e-05) (-0.0006204784, -1.7067338e-05) (-0.00062008799, -1.7028886e-05) (-0.00061959806, -1.7004817e-05) (-0.00061940182, -1.7e-05) (-0.00057559818, -1.7e-05) (-0.00057540194, -1.7004817e-05) (-0.00057491201, -1.7028886e-05) (-0.0005745216, -1.7067338e-05) (-0.00057413354, -1.7124902e-05) (-0.00057374877, -1.7201436e-05) (-0.00057336823, -1.7296759e-05) (-0.00057299281, -1.7410639e-05) (-0.00057262344, -1.7542802e-05) (-0.000572261, -1.7692931e-05) (-0.00057190636, -1.7860663e-05) (-0.00057156038, -1.8045594e-05) (-0.00057122389, -1.8247279e-05) (-0.0005708977, -1.8465232e-05) (-0.0005705826, -1.8698928e-05) (-0.00057027934, -1.8947803e-05) (-0.00056998866, -1.9211259e-05) (-0.00056971126, -1.948866e-05) (-0.0005694478, -1.9779339e-05) (-0.00056919893, -2.0082595e-05) (-0.00056896523, -2.0397697e-05) (-0.00056874728, -2.0723887e-05) (-0.00056854559, -2.1060378e-05) (-0.00056836066, -2.140636e-05) (-0.00056819293, -2.1760999e-05) (-0.0005680428, -2.2123441e-05) (-0.00056791064, -2.2492814e-05) (-0.00056779676, -2.2868226e-05) (-0.00056770144, -2.3248774e-05) (-0.0005676249, -2.3633541e-05) (-0.00056756734, -2.40216e-05) (-0.00056752889, -2.4412015e-05) (-0.00056750482, -2.4901939e-05) (-0.0005675, -2.509818e-05) (-0.0005675, -0.00015190182) (-0.00056750482, -0.00015209806) (-0.00056752889, -0.00015258799) (-0.00056756734, -0.0001529784) (-0.0005676249, -0.00015336646) (-0.00056770144, -0.00015375123) (-0.00056779676, -0.00015413177) (-0.00056791064, -0.00015450719) (-0.0005680428, -0.00015487656) (-0.00056819293, -0.000155239) (-0.00056836066, -0.00015559364) (-0.00056854559, -0.00015593962) (-0.00056874728, -0.00015627611) (-0.00056896523, -0.0001566023) (-0.00056919893, -0.0001569174) (-0.0005694478, -0.00015722066) (-0.00056971126, -0.00015751134) (-0.00056998866, -0.00015778874) (-0.00057027934, -0.0001580522) (-0.0005705826, -0.00015830107) (-0.0005708977, -0.00015853477) (-0.00057122389, -0.00015875272) (-0.00057156038, -0.00015895441) (-0.00057190636, -0.00015913934) (-0.000572261, -0.00015930707) (-0.00057262344, -0.0001594572) (-0.00057299281, -0.00015958936) (-0.00057336823, -0.00015970324) (-0.00057374877, -0.00015979856) (-0.00057413354, -0.0001598751) (-0.0005745216, -0.00015993266) (-0.00057491201, -0.00015997111) (-0.00057540194, -0.00015999518) (-0.00057559818, -0.00016) (-0.00073640182, -0.00016) (-0.00073659806, -0.00015999518) (-0.00073708798, -0.00015997111) (-0.0007374784, -0.00015993266) (-0.00073786646, -0.0001598751) (-0.00073825123, -0.00015979856) (-0.00073863177, -0.00015970324) (-0.00073900719, -0.00015958936) (-0.00073937656, -0.0001594572) (-0.000739739, -0.00015930707) (-0.00074009364, -0.00015913934) (-0.00074043962, -0.00015895441) (-0.00074077611, -0.00015875272) (-0.0007411023, -0.00015853477) (-0.0007414174, -0.00015830107) (-0.00074172066, -0.0001580522) (-0.00074201134, -0.00015778874) (-0.00074228874, -0.00015751134) (-0.0007425522, -0.00015722066) (-0.00074280107, -0.0001569174) (-0.00074303477, -0.0001566023) (-0.00074325272, -0.00015627611) (-0.00074345441, -0.00015593962) (-0.00074363934, -0.00015559364) (-0.00074380707, -0.000155239) (-0.0007439572, -0.00015487656) (-0.00074408936, -0.00015450719) (-0.00074420324, -0.00015413177) (-0.00074429856, -0.00015375123) (-0.0007443751, -0.00015336646) (-0.00074443266, -0.0001529784) (-0.00074447111, -0.00015258799) (-0.00074449518, -0.00015209806) (-0.0007445, -0.00015190182) (-0.0007445, 0.00015190182) (-0.00074449518, 0.00015209806) (-0.00074447111, 0.00015258799) (-0.00074443266, 0.0001529784) (-0.0007443751, 0.00015336646) (-0.00074429856, 0.00015375123) (-0.00074420324, 0.00015413177) (-0.00074408936, 0.00015450719) (-0.0007439572, 0.00015487656) (-0.00074380707, 0.000155239) (-0.00074363934, 0.00015559364) (-0.00074345441, 0.00015593962) (-0.00074325272, 0.00015627611) (-0.00074303477, 0.0001566023) (-0.00074280107, 0.0001569174) (-0.0007425522, 0.00015722066) (-0.00074228874, 0.00015751134) (-0.00074201134, 0.00015778874) (-0.00074172066, 0.0001580522) (-0.0007414174, 0.00015830107) (-0.0007411023, 0.00015853477) (-0.00074077611, 0.00015875272) (-0.00074043962, 0.00015895441) (-0.00074009364, 0.00015913934) (-0.000739739, 0.00015930707) (-0.00073937656, 0.0001594572) (-0.00073900719, 0.00015958936) (-0.00073863177, 0.00015970324) (-0.00073825123, 0.00015979856) (-0.00073786646, 0.0001598751) (-0.0007374784, 0.00015993266) (-0.00073708798, 0.00015997111) (-0.00073659806, 0.00015999518) (-0.00073640182, 0.00016) (-0.00057559818, 0.00016) (-0.00057540194, 0.00015999518) (-0.00057491201, 0.00015997111) (-0.0005745216, 0.00015993266) (-0.00057413354, 0.0001598751) (-0.00057374877, 0.00015979856) (-0.00057336823, 0.00015970324) (-0.00057299281, 0.00015958936) (-0.00057262344, 0.0001594572) (-0.000572261, 0.00015930707) (-0.00057190636, 0.00015913934) (-0.00057156038, 0.00015895441) (-0.00057122389, 0.00015875272) (-0.0005708977, 0.00015853477) (-0.0005705826, 0.00015830107) (-0.00057027934, 0.0001580522) (-0.00056998866, 0.00015778874) (-0.00056971126, 0.00015751134) (-0.0005694478, 0.00015722066) (-0.00056919893, 0.0001569174) (-0.00056896523, 0.0001566023) (-0.00056874728, 0.00015627611) (-0.00056854559, 0.00015593962) (-0.00056836066, 0.00015559364) (-0.00056819293, 0.000155239) (-0.0005680428, 0.00015487656) (-0.00056791064, 0.00015450719) (-0.00056779676, 0.00015413177) (-0.00056770144, 0.00015375123) (-0.0005676249, 0.00015336646) (-0.00056756734, 0.0001529784) (-0.00056752889, 0.00015258799) (-0.00056750482, 0.00015209806) (-0.0005675, 0.00015190182) (-0.0005675, 2.509818e-05) (-0.00056750482, 2.4901939e-05) (-0.00056752889, 2.4412015e-05) (-0.00056756734, 2.40216e-05) (-0.0005676249, 2.3633541e-05) (-0.00056770144, 2.3248774e-05) (-0.00056779676, 2.2868226e-05) (-0.00056791064, 2.2492814e-05) (-0.0005680428, 2.2123441e-05) (-0.00056819293, 2.1760999e-05) (-0.00056836066, 2.140636e-05) (-0.00056854559, 2.1060378e-05) (-0.00056874728, 2.0723887e-05) (-0.00056896523, 2.0397697e-05) (-0.00056919893, 2.0082595e-05) (-0.0005694478, 1.9779339e-05) (-0.00056971126, 1.948866e-05) (-0.00056998866, 1.9211259e-05) (-0.00057027934, 1.8947803e-05) (-0.0005705826, 1.8698928e-05) (-0.0005708977, 1.8465232e-05) (-0.00057122389, 1.8247279e-05) (-0.00057156038, 1.8045594e-05) (-0.00057190636, 1.7860663e-05) (-0.000572261, 1.7692931e-05) (-0.00057262344, 1.7542802e-05) (-0.00057299281, 1.7410639e-05) (-0.00057336823, 1.7296759e-05) (-0.00057374877, 1.7201436e-05) (-0.00057413354, 1.7124902e-05) (-0.0005745216, 1.7067338e-05) (-0.00057491201, 1.7028886e-05) (-0.00057540194, 1.7004817e-05) (-0.00057559818, 1.7e-05) (-0.00061940182, 1.7e-05) (-0.00061959806, 1.7004817e-05) (-0.00062008799, 1.7028886e-05) (-0.0006204784, 1.7067338e-05) (-0.00062086646, 1.7124902e-05) (-0.00062125123, 1.7201436e-05) (-0.00062163177, 1.7296759e-05) (-0.00062200719, 1.7410639e-05) (-0.00062237656, 1.7542802e-05) (-0.000622739, 1.7692931e-05) (-0.00062309364, 1.7860663e-05) (-0.00062343962, 1.8045594e-05) (-0.00062377611, 1.8247279e-05) (-0.0006241023, 1.8465232e-05) (-0.0006244174, 1.8698928e-05) (-0.00062472066, 1.8947803e-05) (-0.00062501134, 1.9211259e-05) (-0.00062528874, 1.948866e-05) (-0.0006255522, 1.9779339e-05) (-0.00062580107, 2.0082595e-05) (-0.00062603477, 2.0397697e-05) (-0.00062625272, 2.0723887e-05) (-0.00062645441, 2.1060378e-05) (-0.00062663934, 2.140636e-05) (-0.00062680707, 2.1760999e-05) (-0.0006269572, 2.2123441e-05) (-0.00062708936, 2.2492814e-05) (-0.00062720324, 2.2868226e-05)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, closed, covered)
  pocket_cin = polyline(z=0, xy: (-0.0007565, -0.00016) (-0.0007565, 0.00016) (-0.00075644222, 0.00016117621) (-0.00075626942, 0.00016234108) (-0.00075598328, 0.00016348342) (-0.00075558655, 0.0001645922) (-0.00075508306, 0.00016565676) (-0.00075447763, 0.00016666684) (-0.00075377612, 0.00016761272) (-0.00075298528, 0.00016848528) (-0.00075211272, 0.00016927613) (-0.00075116684, 0.00016997764) (-0.00075015676, 0.00017058306) (-0.0007490922, 0.00017108655) (-0.00074798342, 0.00017148328) (-0.00074684108, 0.00017176942) (-0.00074567621, 0.00017194222) (-0.0007445, 0.000172) (-0.0005675, 0.000172) (-0.00056632379, 0.00017194222) (-0.00056515892, 0.00017176942) (-0.00056401658, 0.00017148328) (-0.0005629078, 0.00017108655) (-0.00056184324, 0.00017058306) (-0.00056083316, 0.00016997764) (-0.00055988728, 0.00016927613) (-0.00055901472, 0.00016848528) (-0.00055822388, 0.00016761272) (-0.00055752237, 0.00016666684) (-0.00055691694, 0.00016565676) (-0.00055641345, 0.0001645922) (-0.00055601672, 0.00016348342) (-0.00055573058, 0.00016234108) (-0.00055555778, 0.00016117621) (-0.0005555, 0.00016) (-0.0005555, -0.00016) (-0.00055555778, -0.00016117621) (-0.00055573058, -0.00016234108) (-0.00055601672, -0.00016348342) (-0.00055641345, -0.0001645922) (-0.00055691694, -0.00016565676) (-0.00055752237, -0.00016666684) (-0.00055822388, -0.00016761272) (-0.00055901472, -0.00016848528) (-0.00055988728, -0.00016927613) (-0.00056083316, -0.00016997764) (-0.00056184324, -0.00017058306) (-0.0005629078, -0.00017108655) (-0.00056401658, -0.00017148328) (-0.00056515892, -0.00017176942) (-0.00056632379, -0.00017194222) (-0.0005675, -0.000172) (-0.0007445, -0.000172) (-0.00074567621, -0.00017194222) (-0.00074684108, -0.00017176942) (-0.00074798342, -0.00017148328) (-0.0007490922, -0.00017108655) (-0.00075015676, -0.00017058306) (-0.00075116684, -0.00016997764) (-0.00075211272, -0.00016927613) (-0.00075298528, -0.00016848528) (-0.00075377612, -0.00016761272) (-0.00075447763, -0.00016666684) (-0.00075508306, -0.00016565676) (-0.00075558655, -0.0001645922) (-0.00075598328, -0.00016348342) (-0.00075626942, -0.00016234108) (-0.00075644222, -0.00016117621) (-0.0007565, -0.00016), closed, covered)
  tap_trace_n0 = polyline(z=0, xy: (0.00015, -8e-06) (-0.00015, -8e-06) (-0.00015, 8e-06) (-8e-06, 8e-06) (-8e-06, 0.0001) (8e-06, 0.0001) (8e-06, 8e-06) (0.00015, 8e-06) (0.00015, -8e-06), closed, covered)
  tap_cut_n0 = polyline(z=0, xy: (0.00015, -1.7e-05) (-0.00015, -1.7e-05) (-0.00015, 1.7e-05) (-1.7e-05, 1.7e-05) (-1.7e-05, 0.0001) (1.7e-05, 0.0001) (1.7e-05, 1.7e-05) (0.00015, 1.7e-05) (0.00015, -1.7e-05), closed, covered)
  plate_cp = polyline(z=0, xy: (9.1e-05, 0.00027) (9.0961478e-05, 0.00026921586) (9.0846282e-05, 0.00026843928) (9.0655523e-05, 0.00026767772) (9.0391036e-05, 0.00026693853) (9.005537e-05, 0.00026622883) (8.9651757e-05, 0.00026555544) (8.9184084e-05, 0.00026492485) (8.8656854e-05, 0.00026434315) (8.8075146e-05, 0.00026381592) (8.7444562e-05, 0.00026334824) (8.6771174e-05, 0.00026294463) (8.6061467e-05, 0.00026260896) (8.5322277e-05, 0.00026234448) (8.4560723e-05, 0.00026215372) (8.3784137e-05, 0.00026203852) (8.3e-05, 0.000262) (-8.3e-05, 0.000262) (-8.3784137e-05, 0.00026203852) (-8.4560723e-05, 0.00026215372) (-8.5322277e-05, 0.00026234448) (-8.6061467e-05, 0.00026260896) (-8.6771174e-05, 0.00026294463) (-8.7444562e-05, 0.00026334824) (-8.8075146e-05, 0.00026381592) (-8.8656854e-05, 0.00026434315) (-8.9184084e-05, 0.00026492485) (-8.9651757e-05, 0.00026555544) (-9.005537e-05, 0.00026622883) (-9.0391036e-05, 0.00026693853) (-9.0655523e-05, 0.00026767772) (-9.0846282e-05, 0.00026843928) (-9.0961478e-05, 0.00026921586) (-9.1e-05, 0.00027) (-9.1e-05, 0.000295) (-9.0961478e-05, 0.00029578414) (-9.0846282e-05, 0.00029656072) (-9.0655523e-05, 0.00029732228) (-9.0391036e-05, 0.00029806147) (-9.005537e-05, 0.00029877117) (-8.9651757e-05, 0.00029944456) (-8.9184084e-05, 0.00030007515) (-8.8656854e-05, 0.00030065685) (-8.8075146e-05, 0.00030118408) (-8.7444562e-05, 0.00030165176) (-8.6771174e-05, 0.00030205537) (-8.6061467e-05, 0.00030239104) (-8.5322277e-05, 0.00030265552) (-8.4560723e-05, 0.00030284628) (-8.3784137e-05, 0.00030296148) (-8.3e-05, 0.000303) (8.3e-05, 0.000303) (8.3784137e-05, 0.00030296148) (8.4560723e-05, 0.00030284628) (8.5322277e-05, 0.00030265552) (8.6061467e-05, 0.00030239104) (8.6771174e-05, 0.00030205537) (8.7444562e-05, 0.00030165176) (8.8075146e-05, 0.00030118408) (8.8656854e-05, 0.00030065685) (8.9184084e-05, 0.00030007515) (8.9651757e-05, 0.00029944456) (9.005537e-05, 0.00029877117) (9.0391036e-05, 0.00029806147) (9.0655523e-05, 0.00029732228) (9.0846282e-05, 0.00029656072) (9.0961478e-05, 0.00029578414) (9.1e-05, 0.000295) (9.1e-05, 0.00027), closed, covered)
  frame_cp = polyline(z=0, xy: (9.5e-05, 0.00025) (9.5784137e-05, 0.00025003852) (9.6560723e-05, 0.00025015372) (9.7322277e-05, 0.00025034448) (9.8061467e-05, 0.00025060896) (9.8771174e-05, 0.00025094463) (9.9444562e-05, 0.00025134824) (0.00010007515, 0.00025181592) (0.00010065685, 0.00025234315) (0.00010118408, 0.00025292485) (0.00010165176, 0.00025355544) (0.00010205537, 0.00025422883) (0.00010239104, 0.00025493853) (0.00010265552, 0.00025567772) (0.00010284628, 0.00025643928) (0.00010296148, 0.00025721586) (0.000103, 0.000258) (0.000103, 0.000307) (0.00010296148, 0.00030778414) (0.00010284628, 0.00030856072) (0.00010265552, 0.00030932228) (0.00010239104, 0.00031006147) (0.00010205537, 0.00031077117) (0.00010165176, 0.00031144456) (0.00010118408, 0.00031207515) (0.00010065685, 0.00031265685) (0.00010007515, 0.00031318408) (9.9444562e-05, 0.00031365176) (9.8771174e-05, 0.00031405537) (9.8061467e-05, 0.00031439104) (9.7322277e-05, 0.00031465552) (9.6560723e-05, 0.00031484628) (9.5784137e-05, 0.00031496148) (9.5e-05, 0.000315) (2.509818e-05, 0.000315) (2.4901939e-05, 0.00031500482) (2.4412015e-05, 0.00031502889) (2.40216e-05, 0.00031506734) (2.3633541e-05, 0.0003151249) (2.3248774e-05, 0.00031520144) (2.2868226e-05, 0.00031529676) (2.2492814e-05, 0.00031541064) (2.2123441e-05, 0.0003155428) (2.1760999e-05, 0.00031569293) (2.140636e-05, 0.00031586066) (2.1060378e-05, 0.00031604559) (2.0723887e-05, 0.00031624728) (2.0397697e-05, 0.00031646523) (2.0082595e-05, 0.00031669893) (1.9779339e-05, 0.0003169478) (1.948866e-05, 0.00031721126) (1.9211259e-05, 0.00031748866) (1.8947803e-05, 0.00031777934) (1.8698928e-05, 0.00031808259) (1.8465232e-05, 0.0003183977) (1.8247279e-05, 0.00031872389) (1.8045594e-05, 0.00031906038) (1.7860663e-05, 0.00031940636) (1.7692931e-05, 0.000319761) (1.7542802e-05, 0.00032012344) (1.7410639e-05, 0.00032049281) (1.7296759e-05, 0.00032086823) (1.7201436e-05, 0.00032124877) (1.7124902e-05, 0.00032163354) (1.7067338e-05, 0.0003220216) (1.7028886e-05, 0.00032241201) (1.7004817e-05, 0.00032290194) (1.7e-05, 0.00032309818) (1.7e-05, 0.00036690182) (1.7004817e-05, 0.00036709806) (1.7028886e-05, 0.00036758799) (1.7067338e-05, 0.0003679784) (1.7124902e-05, 0.00036836646) (1.7201436e-05, 0.00036875123) (1.7296759e-05, 0.00036913177) (1.7410639e-05, 0.00036950719) (1.7542802e-05, 0.00036987656) (1.7692931e-05, 0.000370239) (1.7860663e-05, 0.00037059364) (1.8045594e-05, 0.00037093962) (1.8247279e-05, 0.00037127611) (1.8465232e-05, 0.0003716023) (1.8698928e-05, 0.0003719174) (1.8947803e-05, 0.00037222066) (1.9211259e-05, 0.00037251134) (1.948866e-05, 0.00037278874) (1.9779339e-05, 0.0003730522) (2.0082595e-05, 0.00037330107) (2.0397697e-05, 0.00037353477) (2.0723887e-05, 0.00037375272) (2.1060378e-05, 0.00037395441) (2.140636e-05, 0.00037413934) (2.1760999e-05, 0.00037430707) (2.2123441e-05, 0.0003744572) (2.2492814e-05, 0.00037458936) (2.2868226e-05, 0.00037470324) (2.3248774e-05, 0.00037479856) (2.3633541e-05, 0.0003748751) (2.40216e-05, 0.00037493266) (2.4412015e-05, 0.00037497111) (2.4901939e-05, 0.00037499518) (2.509818e-05, 0.000375) (0.00015190182, 0.000375) (0.00015209806, 0.00037499518) (0.00015258799, 0.00037497111) (0.0001529784, 0.00037493266) (0.00015336646, 0.0003748751) (0.00015375123, 0.00037479856) (0.00015413177, 0.00037470324) (0.00015450719, 0.00037458936) (0.00015487656, 0.0003744572) (0.000155239, 0.00037430707) (0.00015559364, 0.00037413934) (0.00015593962, 0.00037395441) (0.00015627611, 0.00037375272) (0.0001566023, 0.00037353477) (0.0001569174, 0.00037330107) (0.00015722066, 0.0003730522) (0.00015751134, 0.00037278874) (0.00015778874, 0.00037251134) (0.0001580522, 0.00037222066) (0.00015830107, 0.0003719174) (0.00015853477, 0.0003716023) (0.00015875272, 0.00037127611) (0.00015895441, 0.00037093962) (0.00015913934, 0.00037059364) (0.00015930707, 0.000370239) (0.0001594572, 0.00036987656) (0.00015958936, 0.00036950719) (0.00015970324, 0.00036913177) (0.00015979856, 0.00036875123) (0.0001598751, 0.00036836646) (0.00015993266, 0.0003679784) (0.00015997111, 0.00036758799) (0.00015999518, 0.00036709806) (0.00016, 0.00036690182) (0.00016, 0.00020609818) (0.00015999518, 0.00020590194) (0.00015997111, 0.00020541201) (0.00015993266, 0.0002050216) (0.0001598751, 0.00020463354) (0.00015979856, 0.00020424877) (0.00015970324, 0.00020386823) (0.00015958936, 0.00020349281) (0.0001594572, 0.00020312344) (0.00015930707, 0.000202761) (0.00015913934, 0.00020240636) (0.00015895441, 0.00020206038) (0.00015875272, 0.00020172389) (0.00015853477, 0.0002013977) (0.00015830107, 0.0002010826) (0.0001580522, 0.00020077934) (0.00015778874, 0.00020048866) (0.00015751134, 0.00020021126) (0.00015722066, 0.0001999478) (0.0001569174, 0.00019969893) (0.0001566023, 0.00019946523) (0.00015627611, 0.00019924728) (0.00015593962, 0.00019904559) (0.00015559364, 0.00019886066) (0.000155239, 0.00019869293) (0.00015487656, 0.0001985428) (0.00015450719, 0.00019841064) (0.00015413177, 0.00019829676) (0.00015375123, 0.00019820144) (0.00015336646, 0.0001981249) (0.0001529784, 0.00019806734) (0.00015258799, 0.00019802889) (0.00015209806, 0.00019800482) (0.00015190182, 0.000198) (-0.00015190182, 0.000198) (-0.00015209806, 0.00019800482) (-0.00015258799, 0.00019802889) (-0.0001529784, 0.00019806734) (-0.00015336646, 0.0001981249) (-0.00015375123, 0.00019820144) (-0.00015413177, 0.00019829676) (-0.00015450719, 0.00019841064) (-0.00015487656, 0.0001985428) (-0.000155239, 0.00019869293) (-0.00015559364, 0.00019886066) (-0.00015593962, 0.00019904559) (-0.00015627611, 0.00019924728) (-0.0001566023, 0.00019946523) (-0.0001569174, 0.00019969893) (-0.00015722066, 0.0001999478) (-0.00015751134, 0.00020021126) (-0.00015778874, 0.00020048866) (-0.0001580522, 0.00020077934) (-0.00015830107, 0.0002010826) (-0.00015853477, 0.0002013977) (-0.00015875272, 0.00020172389) (-0.00015895441, 0.00020206038) (-0.00015913934, 0.00020240636) (-0.00015930707, 0.000202761) (-0.0001594572, 0.00020312344) (-0.00015958936, 0.00020349281) (-0.00015970324, 0.00020386823) (-0.00015979856, 0.00020424877) (-0.0001598751, 0.00020463354) (-0.00015993266, 0.0002050216) (-0.00015997111, 0.00020541201) (-0.00015999518, 0.00020590194) (-0.00016, 0.00020609818) (-0.00016, 0.00036690182) (-0.00015999518, 0.00036709806) (-0.00015997111, 0.00036758799) (-0.00015993266, 0.0003679784) (-0.0001598751, 0.00036836646) (-0.00015979856, 0.00036875123) (-0.00015970324, 0.00036913177) (-0.00015958936, 0.00036950719) (-0.0001594572, 0.00036987656) (-0.00015930707, 0.000370239) (-0.00015913934, 0.00037059364) (-0.00015895441, 0.00037093962) (-0.00015875272, 0.00037127611) (-0.00015853477, 0.0003716023) (-0.00015830107, 0.0003719174) (-0.0001580522, 0.00037222066) (-0.00015778874, 0.00037251134) (-0.00015751134, 0.00037278874) (-0.00015722066, 0.0003730522) (-0.0001569174, 0.00037330107) (-0.0001566023, 0.00037353477) (-0.00015627611, 0.00037375272) (-0.00015593962, 0.00037395441) (-0.00015559364, 0.00037413934) (-0.000155239, 0.00037430707) (-0.00015487656, 0.0003744572) (-0.00015450719, 0.00037458936) (-0.00015413177, 0.00037470324) (-0.00015375123, 0.00037479856) (-0.00015336646, 0.0003748751) (-0.0001529784, 0.00037493266) (-0.00015258799, 0.00037497111) (-0.00015209806, 0.00037499518) (-0.00015190182, 0.000375) (-2.509818e-05, 0.000375) (-2.4901939e-05, 0.00037499518) (-2.4412015e-05, 0.00037497111) (-2.40216e-05, 0.00037493266) (-2.3633541e-05, 0.0003748751) (-2.3248774e-05, 0.00037479856) (-2.2868226e-05, 0.00037470324) (-2.2492814e-05, 0.00037458936) (-2.2123441e-05, 0.0003744572) (-2.1760999e-05, 0.00037430707) (-2.140636e-05, 0.00037413934) (-2.1060378e-05, 0.00037395441) (-2.0723887e-05, 0.00037375272) (-2.0397697e-05, 0.00037353477) (-2.0082595e-05, 0.00037330107) (-1.9779339e-05, 0.0003730522) (-1.948866e-05, 0.00037278874) (-1.9211259e-05, 0.00037251134) (-1.8947803e-05, 0.00037222066) (-1.8698928e-05, 0.0003719174) (-1.8465232e-05, 0.0003716023) (-1.8247279e-05, 0.00037127611) (-1.8045594e-05, 0.00037093962) (-1.7860663e-05, 0.00037059364) (-1.7692931e-05, 0.000370239) (-1.7542802e-05, 0.00036987656) (-1.7410639e-05, 0.00036950719) (-1.7296759e-05, 0.00036913177) (-1.7201436e-05, 0.00036875123) (-1.7124902e-05, 0.00036836646) (-1.7067338e-05, 0.0003679784) (-1.7028886e-05, 0.00036758799) (-1.7004817e-05, 0.00036709806) (-1.7e-05, 0.00036690182) (-1.7e-05, 0.00032309818) (-1.7004817e-05, 0.00032290194) (-1.7028886e-05, 0.00032241201) (-1.7067338e-05, 0.0003220216) (-1.7124902e-05, 0.00032163354) (-1.7201436e-05, 0.00032124877) (-1.7296759e-05, 0.00032086823) (-1.7410639e-05, 0.00032049281) (-1.7542802e-05, 0.00032012344) (-1.7692931e-05, 0.000319761) (-1.7860663e-05, 0.00031940636) (-1.8045594e-05, 0.00031906038) (-1.8247279e-05, 0.00031872389) (-1.8465232e-05, 0.0003183977) (-1.8698928e-05, 0.00031808259) (-1.8947803e-05, 0.00031777934) (-1.9211259e-05, 0.00031748866) (-1.948866e-05, 0.00031721126) (-1.9779339e-05, 0.0003169478) (-2.0082595e-05, 0.00031669893) (-2.0397697e-05, 0.00031646523) (-2.0723887e-05, 0.00031624728) (-2.1060378e-05, 0.00031604559) (-2.140636e-05, 0.00031586066) (-2.1760999e-05, 0.00031569293) (-2.2123441e-05, 0.0003155428) (-2.2492814e-05, 0.00031541064) (-2.2868226e-05, 0.00031529676)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, closed, covered)
  pocket_cp = polyline(z=0, xy: (0.00016, 0.000186) (-0.00016, 0.000186) (-0.00016117621, 0.00018605778) (-0.00016234108, 0.00018623058) (-0.00016348342, 0.00018651672) (-0.0001645922, 0.00018691345) (-0.00016565676, 0.00018741695) (-0.00016666684, 0.00018802236) (-0.00016761272, 0.00018872387) (-0.00016848528, 0.00018951472) (-0.00016927613, 0.00019038728) (-0.00016997764, 0.00019133316) (-0.00017058306, 0.00019234324) (-0.00017108655, 0.0001934078) (-0.00017148328, 0.00019451658) (-0.00017176942, 0.00019565892) (-0.00017194222, 0.00019682379) (-0.000172, 0.000198) (-0.000172, 0.000375) (-0.00017194222, 0.00037617621) (-0.00017176942, 0.00037734108) (-0.00017148328, 0.00037848342) (-0.00017108655, 0.0003795922) (-0.00017058306, 0.00038065676) (-0.00016997764, 0.00038166684) (-0.00016927613, 0.00038261272) (-0.00016848528, 0.00038348528) (-0.00016761272, 0.00038427613) (-0.00016666684, 0.00038497764) (-0.00016565676, 0.00038558305) (-0.0001645922, 0.00038608655) (-0.00016348342, 0.00038648328) (-0.00016234108, 0.00038676942) (-0.00016117621, 0.00038694222) (-0.00016, 0.000387) (0.00016, 0.000387) (0.00016117621, 0.00038694222) (0.00016234108, 0.00038676942) (0.00016348342, 0.00038648328) (0.0001645922, 0.00038608655) (0.00016565676, 0.00038558305) (0.00016666684, 0.00038497764) (0.00016761272, 0.00038427613) (0.00016848528, 0.00038348528) (0.00016927613, 0.00038261272) (0.00016997764, 0.00038166684) (0.00017058306, 0.00038065676) (0.00017108655, 0.0003795922) (0.00017148328, 0.00037848342) (0.00017176942, 0.00037734108) (0.00017194222, 0.00037617621) (0.000172, 0.000375) (0.000172, 0.000198) (0.00017194222, 0.00019682379) (0.00017176942, 0.00019565892) (0.00017148328, 0.00019451658) (0.00017108655, 0.0001934078) (0.00017058306, 0.00019234324) (0.00016997764, 0.00019133316) (0.00016927613, 0.00019038728) (0.00016848528, 0.00018951472) (0.00016761272, 0.00018872387) (0.00016666684, 0.00018802236) (0.00016565676, 0.00018741695) (0.0001645922, 0.00018691345) (0.00016348342, 0.00018651672) (0.00016234108, 0.00018623058) (0.00016117621, 0.00018605778) (0.00016, 0.000186), closed, covered)
  tap_trace_jf = polyline(z=0, xy: (-8e-06, 0.001465) (-8e-06, 0.001765) (8e-06, 0.001765) (8e-06, 0.001623) (0.000124, 0.001623) (0.000124, 0.001607) (8e-06, 0.001607) (8e-06, 0.001465) (-8e-06, 0.001465), closed, covered)
  tap_cut_jf = polyline(z=0, xy: (-1.7e-05, 0.001465) (-1.7e-05, 0.001765) (1.7e-05, 0.001765) (1.7e-05, 0.001632) (0.000124, 0.001632) (0.000124, 0.001598) (1.7e-05, 0.001598) (1.7e-05, 0.001465) (-1.7e-05, 0.001465), closed, covered)
  tap_trace_jr = polyline(z=0, xy: (0.000276, 0.001623) (0.000392, 0.001623) (0.000392, 0.001765) (0.000408, 0.001765) (0.000408, 0.001465) (0.000392, 0.001465) (0.000392, 0.001607) (0.000276, 0.001607) (0.000276, 0.001623), closed, covered)
  tap_cut_jr = polyline(z=0, xy: (0.000276, 0.001632) (0.000383, 0.001632) (0.000383, 0.001765) (0.000417, 0.001765) (0.000417, 0.001465) (0.000383, 0.001465) (0.000383, 0.001598) (0.000276, 0.001598) (0.000276, 0.001632), closed, covered)
  head_a_cj = polyline(z=0, xy: (0.000156, 0.0015825) (0.00015580397, 0.0015825096) (0.00015560982, 0.0015825384) (0.00015541943, 0.0015825861) (0.00015523463, 0.0015826522) (0.00015505721, 0.0015827362) (0.00015488886, 0.0015828371) (0.00015473121, 0.001582954) (0.00015458579, 0.0015830858) (0.00015445398, 0.0015832312) (0.00015433706, 0.0015833889) (0.00015423616, 0.0015835572) (0.00015415224, 0.0015837346) (0.00015408612, 0.0015839194) (0.00015403843, 0.0015841098) (0.00015400963, 0.001584304) (0.000154, 0.0015845) (0.000154, 0.0016455) (0.00015400963, 0.001645696) (0.00015403843, 0.0016458902) (0.00015408612, 0.0016460806) (0.00015415224, 0.0016462654) (0.00015423616, 0.0016464428) (0.00015433706, 0.0016466111) (0.00015445398, 0.0016467688) (0.00015458579, 0.0016469142) (0.00015473121, 0.001647046) (0.00015488886, 0.0016471629) (0.00015505721, 0.0016472638) (0.00015523463, 0.0016473478) (0.00015541943, 0.0016474139) (0.00015560982, 0.0016474616) (0.00015580397, 0.0016474904) (0.000156, 0.0016475) (0.000177, 0.0016475) (0.00017719603, 0.0016474904) (0.00017739018, 0.0016474616) (0.00017758057, 0.0016474139) (0.00017776537, 0.0016473478) (0.00017794279, 0.0016472638) (0.00017811114, 0.0016471629) (0.00017826879, 0.001647046) (0.00017841421, 0.0016469142) (0.00017854602, 0.0016467688) (0.00017866294, 0.0016466111) (0.00017876384, 0.0016464428) (0.00017884776, 0.0016462654) (0.00017891388, 0.0016460806) (0.00017896157, 0.0016458902) (0.00017899037, 0.001645696) (0.000179, 0.0016455) (0.000179, 0.0015845) (0.00017899037, 0.001584304) (0.00017896157, 0.0015841098) (0.00017891388, 0.0015839194) (0.00017884776, 0.0015837346) (0.00017876384, 0.0015835572) (0.00017866294, 0.0015833889) (0.00017854602, 0.0015832312) (0.00017841421, 0.0015830858) (0.00017826879, 0.001582954) (0.00017811114, 0.0015828371) (0.00017794279, 0.0015827362) (0.00017776537, 0.0015826522) (0.00017758057, 0.0015825861) (0.00017739018, 0.0015825384) (0.00017719603, 0.0015825096) (0.000177, 0.0015825) (0.000156, 0.0015825), closed, covered)
  head_b_cj = polyline(z=0, xy: (0.000223, 0.0015825) (0.00022280397, 0.0015825096) (0.00022260982, 0.0015825384) (0.00022241943, 0.0015825861) (0.00022223463, 0.0015826522) (0.00022205721, 0.0015827362) (0.00022188886, 0.0015828371) (0.00022173121, 0.001582954) (0.00022158579, 0.0015830858) (0.00022145398, 0.0015832312) (0.00022133706, 0.0015833889) (0.00022123616, 0.0015835572) (0.00022115224, 0.0015837346) (0.00022108612, 0.0015839194) (0.00022103843, 0.0015841098) (0.00022100963, 0.001584304) (0.000221, 0.0015845) (0.000221, 0.0016455) (0.00022100963, 0.001645696) (0.00022103843, 0.0016458902) (0.00022108612, 0.0016460806) (0.00022115224, 0.0016462654) (0.00022123616, 0.0016464428) (0.00022133706, 0.0016466111) (0.00022145398, 0.0016467688) (0.00022158579, 0.0016469142) (0.00022173121, 0.001647046) (0.00022188886, 0.0016471629) (0.00022205721, 0.0016472638) (0.00022223463, 0.0016473478) (0.00022241943, 0.0016474139) (0.00022260982, 0.0016474616) (0.00022280397, 0.0016474904) (0.000223, 0.0016475) (0.000244, 0.0016475) (0.00024419603, 0.0016474904) (0.00024439018, 0.0016474616) (0.00024458057, 0.0016474139) (0.00024476537, 0.0016473478) (0.00024494279, 0.0016472638) (0.00024511114, 0.0016471629) (0.00024526879, 0.001647046) (0.00024541421, 0.0016469142) (0.00024554602, 0.0016467688) (0.00024566294, 0.0016466111) (0.00024576384, 0.0016464428) (0.00024584776, 0.0016462654) (0.00024591388, 0.0016460806) (0.00024596157, 0.0016458902) (0.00024599037, 0.001645696) (0.000246, 0.0016455) (0.000246, 0.0015845) (0.00024599037, 0.001584304) (0.00024596157, 0.0015841098) (0.00024591388, 0.0015839194) (0.00024584776, 0.0015837346) (0.00024576384, 0.0015835572) (0.00024566294, 0.0015833889) (0.00024554602, 0.0015832312) (0.00024541421, 0.0015830858) (0.00024526879, 0.001582954) (0.00024511114, 0.0015828371) (0.00024494279, 0.0015827362) (0.00024476537, 0.0015826522) (0.00024458057, 0.0015825861) (0.00024439018, 0.0015825384) (0.00024419603, 0.0015825096) (0.000244, 0.0015825) (0.000223, 0.0015825), closed, covered)
  pocket_cj = polyline(z=0, xy: (0.00014, 0.0015665) (0.00013980397, 0.0015665096) (0.00013960982, 0.0015665384) (0.00013941943, 0.0015665861) (0.00013923463, 0.0015666522) (0.00013905721, 0.0015667362) (0.00013888886, 0.0015668371) (0.00013873121, 0.001566954) (0.00013858579, 0.0015670858) (0.00013845398, 0.0015672312) (0.00013833706, 0.0015673889) (0.00013823616, 0.0015675572) (0.00013815224, 0.0015677346) (0.00013808612, 0.0015679194) (0.00013803843, 0.0015681098) (0.00013800963, 0.001568304) (0.000138, 0.0015685) (0.000138, 0.0016615) (0.00013800963, 0.001661696) (0.00013803843, 0.0016618902) (0.00013808612, 0.0016620806) (0.00013815224, 0.0016622654) (0.00013823616, 0.0016624428) (0.00013833706, 0.0016626111) (0.00013845398, 0.0016627688) (0.00013858579, 0.0016629142) (0.00013873121, 0.001663046) (0.00013888886, 0.0016631629) (0.00013905721, 0.0016632638) (0.00013923463, 0.0016633478) (0.00013941943, 0.0016634139) (0.00013960982, 0.0016634616) (0.00013980397, 0.0016634904) (0.00014, 0.0016635) (0.00026, 0.0016635) (0.00026019603, 0.0016634904) (0.00026039018, 0.0016634616) (0.00026058057, 0.0016634139) (0.00026076537, 0.0016633478) (0.00026094279, 0.0016632638) (0.00026111114, 0.0016631629) (0.00026126879, 0.001663046) (0.00026141421, 0.0016629142) (0.00026154602, 0.0016627688) (0.00026166294, 0.0016626111) (0.00026176384, 0.0016624428) (0.00026184776, 0.0016622654) (0.00026191388, 0.0016620806) (0.00026196157, 0.0016618902) (0.00026199037, 0.001661696) (0.000262, 0.0016615) (0.000262, 0.0015685) (0.00026199037, 0.001568304) (0.00026196157, 0.0015681098) (0.00026191388, 0.0015679194) (0.00026184776, 0.0015677346) (0.00026176384, 0.0015675572) (0.00026166294, 0.0015673889) (0.00026154602, 0.0015672312) (0.00026141421, 0.0015670858) (0.00026126879, 0.001566954) (0.00026111114, 0.0015668371) (0.00026094279, 0.0015667362) (0.00026076537, 0.0015666522) (0.00026058057, 0.0015665861) (0.00026039018, 0.0015665384) (0.00026019603, 0.0015665096) (0.00026, 0.0015665) (0.00014, 0.0015665), closed, covered)
  open_to_ground_readout_open = rectangle(corner=(0.000383, 0.002915, 0), x_size=3.4e-05, y_size=6e-06)
  endcap_feed_in_start = rectangle(corner=(-0.0016296, -1.76e-05, 0), x_size=9.6e-06, y_size=3.52e-05)
  endcap_feed_out_end = rectangle(corner=(0.00162, -1.76e-05, 0), x_size=9.6e-06, y_size=3.52e-05)
  ground_main_plane = rectangle(corner=(-0.00182, -0.000372, 0), x_size=0.00364, y_size=0.0034945638)
  main [silicon_eps11p5] = box(corner=(-0.00182, -0.000372, -0.0005), size=(0.00364, 0.0034945638, 0.0005))
  sample_holder [vacuum] = box(corner=(-0.00182, -0.000372, -0.00165), size=(0.00364, 0.0034945638, 0.00254))
  ground_main_plane.subtract(lead_b_sub_cin, cut_stub_r, tap_cut_n0, cut_stub_f, cut_filter_tail, pocket_cj, tap_cut_jr, cut_feed_out, open_to_ground_readout_open, cut_stub_p, pocket_cp, lead_a_sub_cin, lead_b_sub_cj, endcap_feed_out_end, cut_res_tail, endcap_feed_in_start, cut_feed_jf, lead_b_sub_cp, pocket_cin, lead_a_sub_cj, cut_feed_in, tap_cut_jf, lead_a_sub_cp, cut_feed_mid, cut_res_open_run)
  Port_feed_in_start = rectangle(corner=(-0.0016296, -8e-06, 0), x_size=9.6e-06, y_size=1.6e-05)
  voltage_line_Port_feed_in_start = polyline((-0.00162, 0, 0) (-0.0016296, 0, 0))
  Port_feed_out_end = rectangle(corner=(0.00162, -8e-06, 0), x_size=9.6e-06, y_size=1.6e-05)
  voltage_line_Port_feed_out_end = polyline((0.00162, 0, 0) (0.0016296, 0, 0))
  g_wb_30 [pec] = bondwire(WireType=LOW WireDiameter=0.015mm NumSides=6 XPadPos=7.75e-05 YPadPos=0.001585 ZPadPos=0 XDir=0 YDir=1 ZDir=0 Distance=6e-05 h1=6e-05 h2=0mm alpha=80deg beta=80deg WhichAxis=Z)
  g_wb_31 [pec] = bondwire(WireType=LOW WireDiameter=0.015mm NumSides=6 XPadPos=0.0003225 YPadPos=0.001585 ZPadPos=0 XDir=0 YDir=1 ZDir=0 Distance=6e-05 h1=6e-05 h2=0mm alpha=80deg beta=80deg WhichAxis=Z)
  g_wb_32 [pec] = bondwire(WireType=LOW WireDiameter=0.015mm NumSides=6 XPadPos=-3.65e-05 YPadPos=3e-05 ZPadPos=0 XDir=0 YDir=-1 ZDir=0 Distance=6e-05 h1=6e-05 h2=0mm alpha=80deg beta=80deg WhichAxis=Z)
  g_wb_33 [pec] = bondwire(WireType=LOW WireDiameter=0.015mm NumSides=6 XPadPos=3.65e-05 YPadPos=-3e-05 ZPadPos=0 XDir=0 YDir=1 ZDir=0 Distance=6e-05 h1=6e-05 h2=0mm alpha=80deg beta=80deg WhichAxis=Z)
  g_wb_34 [pec] = bondwire(WireType=LOW WireDiameter=0.015mm NumSides=6 XPadPos=3e-05 YPadPos=6.45e-05 ZPadPos=0 XDir=-1 YDir=0 ZDir=0 Distance=6e-05 h1=6e-05 h2=0mm alpha=80deg beta=80deg WhichAxis=Z)
  g_wb_35 [pec] = bondwire(WireType=LOW WireDiameter=0.015mm NumSides=6 XPadPos=3e-05 YPadPos=0.0016515 ZPadPos=0 XDir=-1 YDir=0 ZDir=0 Distance=6e-05 h1=6e-05 h2=0mm alpha=80deg beta=80deg WhichAxis=Z)
  g_wb_36 [pec] = bondwire(WireType=LOW WireDiameter=0.015mm NumSides=6 XPadPos=-3e-05 YPadPos=0.0015785 ZPadPos=0 XDir=1 YDir=0 ZDir=0 Distance=6e-05 h1=6e-05 h2=0mm alpha=80deg beta=80deg WhichAxis=Z)
  g_wb_37 [pec] = bondwire(WireType=LOW WireDiameter=0.015mm NumSides=6 XPadPos=0.00043 YPadPos=0.0016515 ZPadPos=0 XDir=-1 YDir=0 ZDir=0 Distance=6e-05 h1=6e-05 h2=0mm alpha=80deg beta=80deg WhichAxis=Z)
  g_wb_38 [pec] = bondwire(WireType=LOW WireDiameter=0.015mm NumSides=6 XPadPos=0.00037 YPadPos=0.0015785 ZPadPos=0 XDir=1 YDir=0 ZDir=0 Distance=6e-05 h1=6e-05 h2=0mm alpha=80deg beta=80deg WhichAxis=Z)
boundaries and excitations:
  PerfE: Perfect E Objects=[lead_a_cin, lead_b_cin, lead_a_cp, lead_b_cp, trace_feed_in, trace_feed_mid, trace_feed_out, trace_stub_p, lead_a_cj, lead_b_cj, trace_stub_f, trace_stub_r, trace_feed_jf, trace_res_open_run, trace_filter_tail, trace_res_tail, plate_cin, frame_cin, tap_trace_n0, plate_cp, frame_cp, tap_trace_jf, tap_trace_jr, head_a_cj, head_b_cj, ground_main_plane]
  LumpPort_feed_in_start: Lumped Port Objects=Port_feed_in_start Modes{Mode1{IntLine{middle of Port_feed_in_start.edge(x at corner) -> middle of Port_feed_in_start.edge(x opposite corner)} CharImp=Zpi RenormImp=50ohm}} Impedance=50ohm
  LumpPort_feed_out_end: Lumped Port Objects=Port_feed_out_end Modes{Mode1{IntLine{middle of Port_feed_out_end.edge(x at corner) -> middle of Port_feed_out_end.edge(x opposite corner)} CharImp=Zpi RenormImp=50ohm}} Impedance=50ohm
mesh:
  cpw_line_mesh: LengthBased Objects=[lead_a_cin, lead_b_cin, trace_feed_in, trace_feed_mid, trace_feed_out, trace_stub_p, trace_stub_f, trace_stub_r, trace_feed_jf, trace_res_open_run, trace_filter_tail, trace_res_tail, plate_cin, frame_cin, tap_trace_n0, tap_trace_jf, tap_trace_jr] MaxLength=10um
  cap_mesh: LengthBased Objects=[lead_a_cp, lead_b_cp, lead_a_cj, lead_b_cj, plate_cp, frame_cp, head_a_cj, head_b_cj] MaxLength=10um
setups:
  Setup: HfssDriven Frequency=6.08GHz MaxDeltaS=0.01 MaximumPasses=3 MinimumPasses=3 MinimumConvergedPasses=1 PercentRefinement=20 BasisOrder=1 PortAccuracy=2
    sweep Sweep: 5.9GHz to 6.25GHz, 3501 points; Type=Fast SaveFields
source amplitudes:
  LumpPort_feed_in_start:1: 1W 0deg
  LumpPort_feed_out_end:1: 0W 0deg
field plots:
  Mesh1: MeshPlots in main on Setup : LastAdaptive at Freq=6.08GHz Phase=0deg
  Mag_E1: E Field in main on Setup : LastAdaptive at Freq=6.08GHz Phase=0deg

design W400g42_allwb_p0um_1745_hfss (HFSS, Eigenmode, model units mm)
geometry:
  lead_a_cin_path = polyline((-0.000744499, 0, 0) (-0.0007925, 0, 0))
  lead_a_cin = polyline((-0.000744499, -8e-06, 0) (-0.000744499, 8e-06, 0))
  lead_a_cin.sweep_along_path(lead_a_cin_path)
  lead_a_sub_cin_path = polyline((-0.000744499, 0, 0) (-0.0007925, 0, 0))
  lead_a_sub_cin = polyline((-0.000744499, -1.7e-05, 0) (-0.000744499, 1.7e-05, 0))
  lead_a_sub_cin.sweep_along_path(lead_a_sub_cin_path)
  lead_b_cin_path = polyline((-0.000639501, 0, 0) (-0.0005275, 0, 0))
  lead_b_cin = polyline((-0.000639501, 8e-06, 0) (-0.000639501, -8e-06, 0))
  lead_b_cin.sweep_along_path(lead_b_cin_path)
  lead_b_sub_cin_path = polyline((-0.000639501, 0, 0) (-0.0005275, 0, 0))
  lead_b_sub_cin = polyline((-0.000639501, 1.7e-05, 0) (-0.000639501, -1.7e-05, 0))
  lead_b_sub_cin.sweep_along_path(lead_b_sub_cin_path)
  lead_a_cp_path = polyline((0, 0.000198001, 0) (0, 0.00015, 0))
  lead_a_cp = polyline((8e-06, 0.000198001, 0) (-8e-06, 0.000198001, 0))
  lead_a_cp.sweep_along_path(lead_a_cp_path)
  lead_a_sub_cp_path = polyline((0, 0.000198001, 0) (0, 0.00015, 0))
  lead_a_sub_cp = polyline((1.7e-05, 0.000198001, 0) (-1.7e-05, 0.000198001, 0))
  lead_a_sub_cp.sweep_along_path(lead_a_sub_cp_path)
  lead_b_cp_path = polyline((0, 0.000302999, 0) (0, 0.000415, 0))
  lead_b_cp = polyline((-8e-06, 0.000302999, 0) (8e-06, 0.000302999, 0))
  lead_b_cp.sweep_along_path(lead_b_cp_path)
  lead_b_sub_cp_path = polyline((0, 0.000302999, 0) (0, 0.000415, 0))
  lead_b_sub_cp = polyline((-1.7e-05, 0.000302999, 0) (1.7e-05, 0.000302999, 0))
  lead_b_sub_cp.sweep_along_path(lead_b_sub_cp_path)
  trace_feed_in_path = polyline((-0.00162, 0, 0) (-0.0007925, 0, 0))
  trace_feed_in = polyline((-0.00162, 8e-06, 0) (-0.00162, -8e-06, 0))
  trace_feed_in.sweep_along_path(trace_feed_in_path)
  cut_feed_in_path = polyline((-0.00162, 0, 0) (-0.0007925, 0, 0))
  cut_feed_in = polyline((-0.00162, 1.7e-05, 0) (-0.00162, -1.7e-05, 0))
  cut_feed_in.sweep_along_path(cut_feed_in_path)
  trace_feed_mid_path = polyline((-0.0005275, 0, 0) (-0.00015, 0, 0))
  trace_feed_mid = polyline((-0.0005275, 8e-06, 0) (-0.0005275, -8e-06, 0))
  trace_feed_mid.sweep_along_path(trace_feed_mid_path)
  cut_feed_mid_path = polyline((-0.0005275, 0, 0) (-0.00015, 0, 0))
  cut_feed_mid = polyline((-0.0005275, 1.7e-05, 0) (-0.0005275, -1.7e-05, 0))
  cut_feed_mid.sweep_along_path(cut_feed_mid_path)
  trace_feed_out_path = polyline((0.00015, 0, 0) (0.00162, 0, 0))
  trace_feed_out = polyline((0.00015, 8e-06, 0) (0.00015, -8e-06, 0))
  trace_feed_out.sweep_along_path(trace_feed_out_path)
  cut_feed_out_path = polyline((0.00015, 0, 0) (0.00162, 0, 0))
  cut_feed_out = polyline((0.00015, 1.7e-05, 0) (0.00015, -1.7e-05, 0))
  cut_feed_out.sweep_along_path(cut_feed_out_path)
  trace_stub_p_path = polyline((0, 0.0001, 0) (0, 0.00015, 0))
  trace_stub_p = polyline((-8e-06, 0.0001, 0) (8e-06, 0.0001, 0))
  trace_stub_p.sweep_along_path(trace_stub_p_path)
  cut_stub_p_path = polyline((0, 0.0001, 0) (0, 0.00015, 0))
  cut_stub_p = polyline((-1.7e-05, 0.0001, 0) (1.7e-05, 0.0001, 0))
  cut_stub_p.sweep_along_path(cut_stub_p_path)
  lead_a_cj_path = polyline((0.000154001, 0.001615, 0) (0.000144, 0.001615, 0))
  lead_a_cj = polyline((0.000154001, 0.001607, 0) (0.000154001, 0.001623, 0))
  lead_a_cj.sweep_along_path(lead_a_cj_path)
  lead_a_sub_cj_path = polyline((0.000154001, 0.001615, 0) (0.000144, 0.001615, 0))
  lead_a_sub_cj = polyline((0.000154001, 0.001598, 0) (0.000154001, 0.001632, 0))
  lead_a_sub_cj.sweep_along_path(lead_a_sub_cj_path)
  lead_b_cj_path = polyline((0.000245999, 0.001615, 0) (0.000256, 0.001615, 0))
  lead_b_cj = polyline((0.000245999, 0.001623, 0) (0.000245999, 0.001607, 0))
  lead_b_cj.sweep_along_path(lead_b_cj_path)
  lead_b_sub_cj_path = polyline((0.000245999, 0.001615, 0) (0.000256, 0.001615, 0))
  lead_b_sub_cj = polyline((0.000245999, 0.001632, 0) (0.000245999, 0.001598, 0))
  lead_b_sub_cj.sweep_along_path(lead_b_sub_cj_path)
  trace_stub_f_path = polyline((0.000124, 0.001615, 0) (0.000144, 0.001615, 0))
  trace_stub_f = polyline((0.000124, 0.001623, 0) (0.000124, 0.001607, 0))
  trace_stub_f.sweep_along_path(trace_stub_f_path)
  cut_stub_f_path = polyline((0.000124, 0.001615, 0) (0.000144, 0.001615, 0))
  cut_stub_f = polyline((0.000124, 0.001632, 0) (0.000124, 0.001598, 0))
  cut_stub_f.sweep_along_path(cut_stub_f_path)
  trace_stub_r_path = polyline((0.000256, 0.001615, 0) (0.000276, 0.001615, 0))
  trace_stub_r = polyline((0.000256, 0.001623, 0) (0.000256, 0.001607, 0))
  trace_stub_r.sweep_along_path(trace_stub_r_path)
  cut_stub_r_path = polyline((0.000256, 0.001615, 0) (0.000276, 0.001615, 0))
  cut_stub_r = polyline((0.000256, 0.001632, 0) (0.000256, 0.001598, 0))
  cut_stub_r.sweep_along_path(cut_stub_r_path)
  trace_feed_jf_path = polyline((0, 0.000415, 0) (0, 0.001465, 0))
  trace_feed_jf = polyline((-8e-06, 0.000415, 0) (8e-06, 0.000415, 0))
  trace_feed_jf.sweep_along_path(trace_feed_jf_path)
  cut_feed_jf_path = polyline((0, 0.000415, 0) (0, 0.001465, 0))
  cut_feed_jf = polyline((-1.7e-05, 0.000415, 0) (1.7e-05, 0.000415, 0))
  cut_feed_jf.sweep_along_path(cut_feed_jf_path)
  trace_res_open_run_path = polyline((0.0004, 0.001765, 0) (0.0004, 0.002915, 0))
  trace_res_open_run = polyline((0.000392, 0.001765, 0) (0.000408, 0.001765, 0))
  trace_res_open_run.sweep_along_path(trace_res_open_run_path)
  cut_res_open_run_path = polyline((0.0004, 0.001765, 0) (0.0004, 0.002915, 0))
  cut_res_open_run = polyline((0.000383, 0.001765, 0) (0.000417, 0.001765, 0))
  cut_res_open_run.sweep_along_path(cut_res_open_run_path)
  trace_filter_tail_path = polyline(z=0, xy: (0, 0.001765) (0, 0.002165) (-0.0004, 0.002165) (-0.0004, 0.00065) (-0.0008, 0.00065) (-0.0008, 0.0012909213))
  trace_filter_tail_path.fillet(Vertices=trace_filter_tail_path.vertex(2 of 6, 3 of 6, 4 of 6, 5 of 6) Radius=9.9e-05 Setback=0mm)
  trace_filter_tail = polyline((-8e-06, 0.001765, 0) (8e-06, 0.001765, 0))
  trace_filter_tail.sweep_along_path(trace_filter_tail_path)
  cut_filter_tail_path = polyline(z=0, xy: (0, 0.001765) (0, 0.002165) (-0.0004, 0.002165) (-0.0004, 0.00065) (-0.0008, 0.00065) (-0.0008, 0.0012909213))
  cut_filter_tail_path.fillet(Vertices=cut_filter_tail_path.vertex(2 of 6, 3 of 6, 4 of 6, 5 of 6) Radius=9.9e-05 Setback=0mm)
  cut_filter_tail = polyline((-1.7e-05, 0.001765, 0) (1.7e-05, 0.001765, 0))
  cut_filter_tail.sweep_along_path(cut_filter_tail_path)
  trace_res_tail_path = polyline(z=0, xy: (0.0004, 0.001465) (0.0004, 0.00065) (0.0008, 0.00065) (0.0008, 0.0029225638))
  trace_res_tail_path.fillet(Vertices=trace_res_tail_path.vertex(2 of 4, 3 of 4) Radius=9.9e-05 Setback=0mm)
  trace_res_tail = polyline((0.000408, 0.001465, 0) (0.000392, 0.001465, 0))
  trace_res_tail.sweep_along_path(trace_res_tail_path)
  cut_res_tail_path = polyline(z=0, xy: (0.0004, 0.001465) (0.0004, 0.00065) (0.0008, 0.00065) (0.0008, 0.0029225638))
  cut_res_tail_path.fillet(Vertices=cut_res_tail_path.vertex(2 of 4, 3 of 4) Radius=9.9e-05 Setback=0mm)
  cut_res_tail = polyline((0.000417, 0.001465, 0) (0.000383, 0.001465, 0))
  cut_res_tail.sweep_along_path(cut_res_tail_path)
  g_wb [pec] = bondwire(WireType=LOW WireDiameter=0.015mm NumSides=6 XPadPos=-0.0013441667 YPadPos=-3.4e-05 ZPadPos=0 XDir=0 YDir=1 ZDir=0 Distance=6.8e-05 h1=6.8e-05 h2=0mm alpha=80deg beta=80deg WhichAxis=Z)
  g_wb_1 [pec] = bondwire(WireType=LOW WireDiameter=0.015mm NumSides=6 XPadPos=-0.0010683333 YPadPos=-3.4e-05 ZPadPos=0 XDir=0 YDir=1 ZDir=0 Distance=6.8e-05 h1=6.8e-05 h2=0mm alpha=80deg beta=80deg WhichAxis=Z)
  g_wb_2 [pec] = bondwire(WireType=LOW WireDiameter=0.015mm NumSides=6 XPadPos=-0.00033875 YPadPos=-3.4e-05 ZPadPos=0 XDir=0 YDir=1 ZDir=0 Distance=6.8e-05 h1=6.8e-05 h2=0mm alpha=80deg beta=80deg WhichAxis=Z)
  g_wb_3 [pec] = bondwire(WireType=LOW WireDiameter=0.015mm NumSides=6 XPadPos=0.000444 YPadPos=-3.4e-05 ZPadPos=0 XDir=0 YDir=1 ZDir=0 Distance=6.8e-05 h1=6.8e-05 h2=0mm alpha=80deg beta=80deg WhichAxis=Z)
  g_wb_4 [pec] = bondwire(WireType=LOW WireDiameter=0.015mm NumSides=6 XPadPos=0.000738 YPadPos=-3.4e-05 ZPadPos=0 XDir=0 YDir=1 ZDir=0 Distance=6.8e-05 h1=6.8e-05 h2=0mm alpha=80deg beta=80deg WhichAxis=Z)
  g_wb_5 [pec] = bondwire(WireType=LOW WireDiameter=0.015mm NumSides=6 XPadPos=0.001032 YPadPos=-3.4e-05 ZPadPos=0 XDir=0 YDir=1 ZDir=0 Distance=6.8e-05 h1=6.8e-05 h2=0mm alpha=80deg beta=80deg WhichAxis=Z)
  g_wb_6 [pec] = bondwire(WireType=LOW WireDiameter=0.015mm NumSides=6 XPadPos=0.001326 YPadPos=-3.4e-05 ZPadPos=0 XDir=0 YDir=1 ZDir=0 Distance=6.8e-05 h1=6.8e-05 h2=0mm alpha=80deg beta=80deg WhichAxis=Z)
  g_wb_7 [pec] = bondwire(WireType=LOW WireDiameter=0.015mm NumSides=6 XPadPos=3.4e-05 YPadPos=0.0006775 ZPadPos=0 XDir=-1 YDir=0 ZDir=0 Distance=6.8e-05 h1=6.8e-05 h2=0mm alpha=80deg beta=80deg WhichAxis=Z)
  g_wb_8 [pec] = bondwire(WireType=LOW WireDiameter=0.015mm NumSides=6 XPadPos=3.4e-05 YPadPos=0.00094 ZPadPos=0 XDir=-1 YDir=0 ZDir=0 Distance=6.8e-05 h1=6.8e-05 h2=0mm alpha=80deg beta=80deg WhichAxis=Z)
  g_wb_9 [pec] = bondwire(WireType=LOW WireDiameter=0.015mm NumSides=6 XPadPos=3.4e-05 YPadPos=0.0012025 ZPadPos=0 XDir=-1 YDir=0 ZDir=0 Distance=6.8e-05 h1=6.8e-05 h2=0mm alpha=80deg beta=80deg WhichAxis=Z)
  g_wb_10 [pec] = bondwire(WireType=LOW WireDiameter=0.015mm NumSides=6 XPadPos=0.000434 YPadPos=0.0020525 ZPadPos=0 XDir=-1 YDir=0 ZDir=0 Distance=6.8e-05 h1=6.8e-05 h2=0mm alpha=80deg beta=80deg WhichAxis=Z)
  g_wb_11 [pec] = bondwire(WireType=LOW WireDiameter=0.015mm NumSides=6 XPadPos=0.000434 YPadPos=0.00234 ZPadPos=0 XDir=-1 YDir=0 ZDir=0 Distance=6.8e-05 h1=6.8e-05 h2=0mm alpha=80deg beta=80deg WhichAxis=Z)
  g_wb_12 [pec] = bondwire(WireType=LOW WireDiameter=0.015mm NumSides=6 XPadPos=0.000434 YPadPos=0.0026275 ZPadPos=0 XDir=-1 YDir=0 ZDir=0 Distance=6.8e-05 h1=6.8e-05 h2=0mm alpha=80deg beta=80deg WhichAxis=Z)
  g_wb_13 [pec] = bondwire(WireType=LOW WireDiameter=0.015mm NumSides=6 XPadPos=3.4e-05 YPadPos=0.001965 ZPadPos=0 XDir=-1 YDir=0 ZDir=0 Distance=6.8e-05 h1=6.8e-05 h2=0mm alpha=80deg beta=80deg WhichAxis=Z)
  g_wb_14 [pec] = bondwire(WireType=LOW WireDiameter=0.015mm NumSides=6 XPadPos=-0.0002 YPadPos=0.002199 ZPadPos=0 XDir=0 YDir=-1 ZDir=0 Distance=6.8e-05 h1=6.8e-05 h2=0mm alpha=80deg beta=80deg WhichAxis=Z)
  g_wb_15 [pec] = bondwire(WireType=LOW WireDiameter=0.015mm NumSides=6 XPadPos=-0.000434 YPadPos=0.001862 ZPadPos=0 XDir=1 YDir=0 ZDir=0 Distance=6.8e-05 h1=6.8e-05 h2=0mm alpha=80deg beta=80deg WhichAxis=Z)
  g_wb_16 [pec] = bondwire(WireType=LOW WireDiameter=0.015mm NumSides=6 XPadPos=-0.000434 YPadPos=0.001559 ZPadPos=0 XDir=1 YDir=0 ZDir=0 Distance=6.8e-05 h1=6.8e-05 h2=0mm alpha=80deg beta=80deg WhichAxis=Z)
  g_wb_17 [pec] = bondwire(WireType=LOW WireDiameter=0.015mm NumSides=6 XPadPos=-0.000434 YPadPos=0.001256 ZPadPos=0 XDir=1 YDir=0 ZDir=0 Distance=6.8e-05 h1=6.8e-05 h2=0mm alpha=80deg beta=80deg WhichAxis=Z)
  g_wb_18 [pec] = bondwire(WireType=LOW WireDiameter=0.015mm NumSides=6 XPadPos=-0.000434 YPadPos=0.000953 ZPadPos=0 XDir=1 YDir=0 ZDir=0 Distance=6.8e-05 h1=6.8e-05 h2=0mm alpha=80deg beta=80deg WhichAxis=Z)
  g_wb_19 [pec] = bondwire(WireType=LOW WireDiameter=0.015mm NumSides=6 XPadPos=-0.0006 YPadPos=0.000684 ZPadPos=0 XDir=0 YDir=-1 ZDir=0 Distance=6.8e-05 h1=6.8e-05 h2=0mm alpha=80deg beta=80deg WhichAxis=Z)
  g_wb_20 [pec] = bondwire(WireType=LOW WireDiameter=0.015mm NumSides=6 XPadPos=-0.000766 YPadPos=0.00097046066 ZPadPos=0 XDir=-1 YDir=0 ZDir=0 Distance=6.8e-05 h1=6.8e-05 h2=0mm alpha=80deg beta=80deg WhichAxis=Z)
  g_wb_21 [pec] = bondwire(WireType=LOW WireDiameter=0.015mm NumSides=6 XPadPos=0.000366 YPadPos=0.0011933333 ZPadPos=0 XDir=1 YDir=0 ZDir=0 Distance=6.8e-05 h1=6.8e-05 h2=0mm alpha=80deg beta=80deg WhichAxis=Z)
  g_wb_22 [pec] = bondwire(WireType=LOW WireDiameter=0.015mm NumSides=6 XPadPos=0.000366 YPadPos=0.00092166667 ZPadPos=0 XDir=1 YDir=0 ZDir=0 Distance=6.8e-05 h1=6.8e-05 h2=0mm alpha=80deg beta=80deg WhichAxis=Z)
  g_wb_23 [pec] = bondwire(WireType=LOW WireDiameter=0.015mm NumSides=6 XPadPos=0.0006 YPadPos=0.000616 ZPadPos=0 XDir=0 YDir=1 ZDir=0 Distance=6.8e-05 h1=6.8e-05 h2=0mm alpha=80deg beta=80deg WhichAxis=Z)
  g_wb_24 [pec] = bondwire(WireType=LOW WireDiameter=0.015mm NumSides=6 XPadPos=0.000834 YPadPos=0.00097465197 ZPadPos=0 XDir=-1 YDir=0 ZDir=0 Distance=6.8e-05 h1=6.8e-05 h2=0mm alpha=80deg beta=80deg WhichAxis=Z)
  g_wb_25 [pec] = bondwire(WireType=LOW WireDiameter=0.015mm NumSides=6 XPadPos=0.000834 YPadPos=0.0012993039 ZPadPos=0 XDir=-1 YDir=0 ZDir=0 Distance=6.8e-05 h1=6.8e-05 h2=0mm alpha=80deg beta=80deg WhichAxis=Z)
  g_wb_26 [pec] = bondwire(WireType=LOW WireDiameter=0.015mm NumSides=6 XPadPos=0.000834 YPadPos=0.0016239559 ZPadPos=0 XDir=-1 YDir=0 ZDir=0 Distance=6.8e-05 h1=6.8e-05 h2=0mm alpha=80deg beta=80deg WhichAxis=Z)
  g_wb_27 [pec] = bondwire(WireType=LOW WireDiameter=0.015mm NumSides=6 XPadPos=0.000834 YPadPos=0.0019486079 ZPadPos=0 XDir=-1 YDir=0 ZDir=0 Distance=6.8e-05 h1=6.8e-05 h2=0mm alpha=80deg beta=80deg WhichAxis=Z)
  g_wb_28 [pec] = bondwire(WireType=LOW WireDiameter=0.015mm NumSides=6 XPadPos=0.000834 YPadPos=0.0022732598 ZPadPos=0 XDir=-1 YDir=0 ZDir=0 Distance=6.8e-05 h1=6.8e-05 h2=0mm alpha=80deg beta=80deg WhichAxis=Z)
  g_wb_29 [pec] = bondwire(WireType=LOW WireDiameter=0.015mm NumSides=6 XPadPos=0.000834 YPadPos=0.0025979118 ZPadPos=0 XDir=-1 YDir=0 ZDir=0 Distance=6.8e-05 h1=6.8e-05 h2=0mm alpha=80deg beta=80deg WhichAxis=Z)
  plate_cin = polyline(z=0, xy: (-0.0006725, -9.1e-05) (-0.00067328414, -9.0961478e-05) (-0.00067406072, -9.0846282e-05) (-0.00067482228, -9.0655523e-05) (-0.00067556147, -9.0391036e-05) (-0.00067627117, -9.005537e-05) (-0.00067694456, -8.9651757e-05) (-0.00067757515, -8.9184084e-05) (-0.00067815685, -8.8656854e-05) (-0.00067868408, -8.8075146e-05) (-0.00067915176, -8.7444562e-05) (-0.00067955537, -8.6771174e-05) (-0.00067989104, -8.6061467e-05) (-0.00068015552, -8.5322277e-05) (-0.00068034628, -8.4560723e-05) (-0.00068046148, -8.3784137e-05) (-0.0006805, -8.3e-05) (-0.0006805, 8.3e-05) (-0.00068046148, 8.3784137e-05) (-0.00068034628, 8.4560723e-05) (-0.00068015552, 8.5322277e-05) (-0.00067989104, 8.6061467e-05) (-0.00067955537, 8.6771174e-05) (-0.00067915176, 8.7444562e-05) (-0.00067868408, 8.8075146e-05) (-0.00067815685, 8.8656854e-05) (-0.00067757515, 8.9184084e-05) (-0.00067694456, 8.9651757e-05) (-0.00067627117, 9.005537e-05) (-0.00067556147, 9.0391036e-05) (-0.00067482228, 9.0655523e-05) (-0.00067406072, 9.0846282e-05) (-0.00067328414, 9.0961478e-05) (-0.0006725, 9.1e-05) (-0.0006475, 9.1e-05) (-0.00064671586, 9.0961478e-05) (-0.00064593928, 9.0846282e-05) (-0.00064517772, 9.0655523e-05) (-0.00064443853, 9.0391036e-05) (-0.00064372883, 9.005537e-05) (-0.00064305544, 8.9651757e-05) (-0.00064242485, 8.9184084e-05) (-0.00064184315, 8.8656854e-05) (-0.00064131592, 8.8075146e-05) (-0.00064084824, 8.7444562e-05) (-0.00064044463, 8.6771174e-05) (-0.00064010896, 8.6061467e-05) (-0.00063984448, 8.5322277e-05) (-0.00063965372, 8.4560723e-05) (-0.00063953852, 8.3784137e-05) (-0.0006395, 8.3e-05) (-0.0006395, -8.3e-05) (-0.00063953852, -8.3784137e-05) (-0.00063965372, -8.4560723e-05) (-0.00063984448, -8.5322277e-05) (-0.00064010896, -8.6061467e-05) (-0.00064044463, -8.6771174e-05) (-0.00064084824, -8.7444562e-05) (-0.00064131592, -8.8075146e-05) (-0.00064184315, -8.8656854e-05) (-0.00064242485, -8.9184084e-05) (-0.00064305544, -8.9651757e-05) (-0.00064372883, -9.005537e-05) (-0.00064443853, -9.0391036e-05) (-0.00064517772, -9.0655523e-05) (-0.00064593928, -9.0846282e-05) (-0.00064671586, -9.0961478e-05) (-0.0006475, -9.1e-05) (-0.0006725, -9.1e-05), closed, covered)
  frame_cin = polyline(z=0, xy: (-0.0006925, -9.5e-05) (-0.00069246148, -9.5784137e-05) (-0.00069234628, -9.6560723e-05) (-0.00069215552, -9.7322277e-05) (-0.00069189104, -9.8061467e-05) (-0.00069155537, -9.8771174e-05) (-0.00069115176, -9.9444562e-05) (-0.00069068408, -0.00010007515) (-0.00069015685, -0.00010065685) (-0.00068957515, -0.00010118408) (-0.00068894456, -0.00010165176) (-0.00068827117, -0.00010205537) (-0.00068756147, -0.00010239104) (-0.00068682228, -0.00010265552) (-0.00068606072, -0.00010284628) (-0.00068528414, -0.00010296148) (-0.0006845, -0.000103) (-0.0006355, -0.000103) (-0.00063471586, -0.00010296148) (-0.00063393928, -0.00010284628) (-0.00063317772, -0.00010265552) (-0.00063243853, -0.00010239104) (-0.00063172883, -0.00010205537) (-0.00063105544, -0.00010165176) (-0.00063042485, -0.00010118408) (-0.00062984315, -0.00010065685) (-0.00062931592, -0.00010007515) (-0.00062884824, -9.9444562e-05) (-0.00062844463, -9.8771174e-05) (-0.00062810896, -9.8061467e-05) (-0.00062784448, -9.7322277e-05) (-0.00062765372, -9.6560723e-05) (-0.00062753852, -9.5784137e-05) (-0.0006275, -9.5e-05) (-0.0006275, -2.509818e-05) (-0.00062749518, -2.4901939e-05) (-0.00062747111, -2.4412015e-05) (-0.00062743266, -2.40216e-05) (-0.0006273751, -2.3633541e-05) (-0.00062729856, -2.3248774e-05) (-0.00062720324, -2.2868226e-05) (-0.00062708936, -2.2492814e-05) (-0.0006269572, -2.2123441e-05) (-0.00062680707, -2.1760999e-05) (-0.00062663934, -2.140636e-05) (-0.00062645441, -2.1060378e-05) (-0.00062625272, -2.0723887e-05) (-0.00062603477, -2.0397697e-05) (-0.00062580107, -2.0082595e-05) (-0.0006255522, -1.9779339e-05) (-0.00062528874, -1.948866e-05) (-0.00062501134, -1.9211259e-05) (-0.00062472066, -1.8947803e-05) (-0.0006244174, -1.8698928e-05) (-0.0006241023, -1.8465232e-05) (-0.00062377611, -1.8247279e-05) (-0.00062343962, -1.8045594e-05) (-0.00062309364, -1.7860663e-05) (-0.000622739, -1.7692931e-05) (-0.00062237656, -1.7542802e-05) (-0.00062200719, -1.7410639e-05) (-0.00062163177, -1.7296759e-05) (-0.00062125123, -1.7201436e-05) (-0.00062086646, -1.7124902e-05) (-0.0006204784, -1.7067338e-05) (-0.00062008799, -1.7028886e-05) (-0.00061959806, -1.7004817e-05) (-0.00061940182, -1.7e-05) (-0.00057559818, -1.7e-05) (-0.00057540194, -1.7004817e-05) (-0.00057491201, -1.7028886e-05) (-0.0005745216, -1.7067338e-05) (-0.00057413354, -1.7124902e-05) (-0.00057374877, -1.7201436e-05) (-0.00057336823, -1.7296759e-05) (-0.00057299281, -1.7410639e-05) (-0.00057262344, -1.7542802e-05) (-0.000572261, -1.7692931e-05) (-0.00057190636, -1.7860663e-05) (-0.00057156038, -1.8045594e-05) (-0.00057122389, -1.8247279e-05) (-0.0005708977, -1.8465232e-05) (-0.0005705826, -1.8698928e-05) (-0.00057027934, -1.8947803e-05) (-0.00056998866, -1.9211259e-05) (-0.00056971126, -1.948866e-05) (-0.0005694478, -1.9779339e-05) (-0.00056919893, -2.0082595e-05) (-0.00056896523, -2.0397697e-05) (-0.00056874728, -2.0723887e-05) (-0.00056854559, -2.1060378e-05) (-0.00056836066, -2.140636e-05) (-0.00056819293, -2.1760999e-05) (-0.0005680428, -2.2123441e-05) (-0.00056791064, -2.2492814e-05) (-0.00056779676, -2.2868226e-05) (-0.00056770144, -2.3248774e-05) (-0.0005676249, -2.3633541e-05) (-0.00056756734, -2.40216e-05) (-0.00056752889, -2.4412015e-05) (-0.00056750482, -2.4901939e-05) (-0.0005675, -2.509818e-05) (-0.0005675, -0.00015190182) (-0.00056750482, -0.00015209806) (-0.00056752889, -0.00015258799) (-0.00056756734, -0.0001529784) (-0.0005676249, -0.00015336646) (-0.00056770144, -0.00015375123) (-0.00056779676, -0.00015413177) (-0.00056791064, -0.00015450719) (-0.0005680428, -0.00015487656) (-0.00056819293, -0.000155239) (-0.00056836066, -0.00015559364) (-0.00056854559, -0.00015593962) (-0.00056874728, -0.00015627611) (-0.00056896523, -0.0001566023) (-0.00056919893, -0.0001569174) (-0.0005694478, -0.00015722066) (-0.00056971126, -0.00015751134) (-0.00056998866, -0.00015778874) (-0.00057027934, -0.0001580522) (-0.0005705826, -0.00015830107) (-0.0005708977, -0.00015853477) (-0.00057122389, -0.00015875272) (-0.00057156038, -0.00015895441) (-0.00057190636, -0.00015913934) (-0.000572261, -0.00015930707) (-0.00057262344, -0.0001594572) (-0.00057299281, -0.00015958936) (-0.00057336823, -0.00015970324) (-0.00057374877, -0.00015979856) (-0.00057413354, -0.0001598751) (-0.0005745216, -0.00015993266) (-0.00057491201, -0.00015997111) (-0.00057540194, -0.00015999518) (-0.00057559818, -0.00016) (-0.00073640182, -0.00016) (-0.00073659806, -0.00015999518) (-0.00073708798, -0.00015997111) (-0.0007374784, -0.00015993266) (-0.00073786646, -0.0001598751) (-0.00073825123, -0.00015979856) (-0.00073863177, -0.00015970324) (-0.00073900719, -0.00015958936) (-0.00073937656, -0.0001594572) (-0.000739739, -0.00015930707) (-0.00074009364, -0.00015913934) (-0.00074043962, -0.00015895441) (-0.00074077611, -0.00015875272) (-0.0007411023, -0.00015853477) (-0.0007414174, -0.00015830107) (-0.00074172066, -0.0001580522) (-0.00074201134, -0.00015778874) (-0.00074228874, -0.00015751134) (-0.0007425522, -0.00015722066) (-0.00074280107, -0.0001569174) (-0.00074303477, -0.0001566023) (-0.00074325272, -0.00015627611) (-0.00074345441, -0.00015593962) (-0.00074363934, -0.00015559364) (-0.00074380707, -0.000155239) (-0.0007439572, -0.00015487656) (-0.00074408936, -0.00015450719) (-0.00074420324, -0.00015413177) (-0.00074429856, -0.00015375123) (-0.0007443751, -0.00015336646) (-0.00074443266, -0.0001529784) (-0.00074447111, -0.00015258799) (-0.00074449518, -0.00015209806) (-0.0007445, -0.00015190182) (-0.0007445, 0.00015190182) (-0.00074449518, 0.00015209806) (-0.00074447111, 0.00015258799) (-0.00074443266, 0.0001529784) (-0.0007443751, 0.00015336646) (-0.00074429856, 0.00015375123) (-0.00074420324, 0.00015413177) (-0.00074408936, 0.00015450719) (-0.0007439572, 0.00015487656) (-0.00074380707, 0.000155239) (-0.00074363934, 0.00015559364) (-0.00074345441, 0.00015593962) (-0.00074325272, 0.00015627611) (-0.00074303477, 0.0001566023) (-0.00074280107, 0.0001569174) (-0.0007425522, 0.00015722066) (-0.00074228874, 0.00015751134) (-0.00074201134, 0.00015778874) (-0.00074172066, 0.0001580522) (-0.0007414174, 0.00015830107) (-0.0007411023, 0.00015853477) (-0.00074077611, 0.00015875272) (-0.00074043962, 0.00015895441) (-0.00074009364, 0.00015913934) (-0.000739739, 0.00015930707) (-0.00073937656, 0.0001594572) (-0.00073900719, 0.00015958936) (-0.00073863177, 0.00015970324) (-0.00073825123, 0.00015979856) (-0.00073786646, 0.0001598751) (-0.0007374784, 0.00015993266) (-0.00073708798, 0.00015997111) (-0.00073659806, 0.00015999518) (-0.00073640182, 0.00016) (-0.00057559818, 0.00016) (-0.00057540194, 0.00015999518) (-0.00057491201, 0.00015997111) (-0.0005745216, 0.00015993266) (-0.00057413354, 0.0001598751) (-0.00057374877, 0.00015979856) (-0.00057336823, 0.00015970324) (-0.00057299281, 0.00015958936) (-0.00057262344, 0.0001594572) (-0.000572261, 0.00015930707) (-0.00057190636, 0.00015913934) (-0.00057156038, 0.00015895441) (-0.00057122389, 0.00015875272) (-0.0005708977, 0.00015853477) (-0.0005705826, 0.00015830107) (-0.00057027934, 0.0001580522) (-0.00056998866, 0.00015778874) (-0.00056971126, 0.00015751134) (-0.0005694478, 0.00015722066) (-0.00056919893, 0.0001569174) (-0.00056896523, 0.0001566023) (-0.00056874728, 0.00015627611) (-0.00056854559, 0.00015593962) (-0.00056836066, 0.00015559364) (-0.00056819293, 0.000155239) (-0.0005680428, 0.00015487656) (-0.00056791064, 0.00015450719) (-0.00056779676, 0.00015413177) (-0.00056770144, 0.00015375123) (-0.0005676249, 0.00015336646) (-0.00056756734, 0.0001529784) (-0.00056752889, 0.00015258799) (-0.00056750482, 0.00015209806) (-0.0005675, 0.00015190182) (-0.0005675, 2.509818e-05) (-0.00056750482, 2.4901939e-05) (-0.00056752889, 2.4412015e-05) (-0.00056756734, 2.40216e-05) (-0.0005676249, 2.3633541e-05) (-0.00056770144, 2.3248774e-05) (-0.00056779676, 2.2868226e-05) (-0.00056791064, 2.2492814e-05) (-0.0005680428, 2.2123441e-05) (-0.00056819293, 2.1760999e-05) (-0.00056836066, 2.140636e-05) (-0.00056854559, 2.1060378e-05) (-0.00056874728, 2.0723887e-05) (-0.00056896523, 2.0397697e-05) (-0.00056919893, 2.0082595e-05) (-0.0005694478, 1.9779339e-05) (-0.00056971126, 1.948866e-05) (-0.00056998866, 1.9211259e-05) (-0.00057027934, 1.8947803e-05) (-0.0005705826, 1.8698928e-05) (-0.0005708977, 1.8465232e-05) (-0.00057122389, 1.8247279e-05) (-0.00057156038, 1.8045594e-05) (-0.00057190636, 1.7860663e-05) (-0.000572261, 1.7692931e-05) (-0.00057262344, 1.7542802e-05) (-0.00057299281, 1.7410639e-05) (-0.00057336823, 1.7296759e-05) (-0.00057374877, 1.7201436e-05) (-0.00057413354, 1.7124902e-05) (-0.0005745216, 1.7067338e-05) (-0.00057491201, 1.7028886e-05) (-0.00057540194, 1.7004817e-05) (-0.00057559818, 1.7e-05) (-0.00061940182, 1.7e-05) (-0.00061959806, 1.7004817e-05) (-0.00062008799, 1.7028886e-05) (-0.0006204784, 1.7067338e-05) (-0.00062086646, 1.7124902e-05) (-0.00062125123, 1.7201436e-05) (-0.00062163177, 1.7296759e-05) (-0.00062200719, 1.7410639e-05) (-0.00062237656, 1.7542802e-05) (-0.000622739, 1.7692931e-05) (-0.00062309364, 1.7860663e-05) (-0.00062343962, 1.8045594e-05) (-0.00062377611, 1.8247279e-05) (-0.0006241023, 1.8465232e-05) (-0.0006244174, 1.8698928e-05) (-0.00062472066, 1.8947803e-05) (-0.00062501134, 1.9211259e-05) (-0.00062528874, 1.948866e-05) (-0.0006255522, 1.9779339e-05) (-0.00062580107, 2.0082595e-05) (-0.00062603477, 2.0397697e-05) (-0.00062625272, 2.0723887e-05) (-0.00062645441, 2.1060378e-05) (-0.00062663934, 2.140636e-05) (-0.00062680707, 2.1760999e-05) (-0.0006269572, 2.2123441e-05) (-0.00062708936, 2.2492814e-05) (-0.00062720324, 2.2868226e-05)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, closed, covered)
  pocket_cin = polyline(z=0, xy: (-0.0007565, -0.00016) (-0.0007565, 0.00016) (-0.00075644222, 0.00016117621) (-0.00075626942, 0.00016234108) (-0.00075598328, 0.00016348342) (-0.00075558655, 0.0001645922) (-0.00075508306, 0.00016565676) (-0.00075447763, 0.00016666684) (-0.00075377612, 0.00016761272) (-0.00075298528, 0.00016848528) (-0.00075211272, 0.00016927613) (-0.00075116684, 0.00016997764) (-0.00075015676, 0.00017058306) (-0.0007490922, 0.00017108655) (-0.00074798342, 0.00017148328) (-0.00074684108, 0.00017176942) (-0.00074567621, 0.00017194222) (-0.0007445, 0.000172) (-0.0005675, 0.000172) (-0.00056632379, 0.00017194222) (-0.00056515892, 0.00017176942) (-0.00056401658, 0.00017148328) (-0.0005629078, 0.00017108655) (-0.00056184324, 0.00017058306) (-0.00056083316, 0.00016997764) (-0.00055988728, 0.00016927613) (-0.00055901472, 0.00016848528) (-0.00055822388, 0.00016761272) (-0.00055752237, 0.00016666684) (-0.00055691694, 0.00016565676) (-0.00055641345, 0.0001645922) (-0.00055601672, 0.00016348342) (-0.00055573058, 0.00016234108) (-0.00055555778, 0.00016117621) (-0.0005555, 0.00016) (-0.0005555, -0.00016) (-0.00055555778, -0.00016117621) (-0.00055573058, -0.00016234108) (-0.00055601672, -0.00016348342) (-0.00055641345, -0.0001645922) (-0.00055691694, -0.00016565676) (-0.00055752237, -0.00016666684) (-0.00055822388, -0.00016761272) (-0.00055901472, -0.00016848528) (-0.00055988728, -0.00016927613) (-0.00056083316, -0.00016997764) (-0.00056184324, -0.00017058306) (-0.0005629078, -0.00017108655) (-0.00056401658, -0.00017148328) (-0.00056515892, -0.00017176942) (-0.00056632379, -0.00017194222) (-0.0005675, -0.000172) (-0.0007445, -0.000172) (-0.00074567621, -0.00017194222) (-0.00074684108, -0.00017176942) (-0.00074798342, -0.00017148328) (-0.0007490922, -0.00017108655) (-0.00075015676, -0.00017058306) (-0.00075116684, -0.00016997764) (-0.00075211272, -0.00016927613) (-0.00075298528, -0.00016848528) (-0.00075377612, -0.00016761272) (-0.00075447763, -0.00016666684) (-0.00075508306, -0.00016565676) (-0.00075558655, -0.0001645922) (-0.00075598328, -0.00016348342) (-0.00075626942, -0.00016234108) (-0.00075644222, -0.00016117621) (-0.0007565, -0.00016), closed, covered)
  tap_trace_n0 = polyline(z=0, xy: (0.00015, -8e-06) (-0.00015, -8e-06) (-0.00015, 8e-06) (-8e-06, 8e-06) (-8e-06, 0.0001) (8e-06, 0.0001) (8e-06, 8e-06) (0.00015, 8e-06) (0.00015, -8e-06), closed, covered)
  tap_cut_n0 = polyline(z=0, xy: (0.00015, -1.7e-05) (-0.00015, -1.7e-05) (-0.00015, 1.7e-05) (-1.7e-05, 1.7e-05) (-1.7e-05, 0.0001) (1.7e-05, 0.0001) (1.7e-05, 1.7e-05) (0.00015, 1.7e-05) (0.00015, -1.7e-05), closed, covered)
  plate_cp = polyline(z=0, xy: (9.1e-05, 0.00027) (9.0961478e-05, 0.00026921586) (9.0846282e-05, 0.00026843928) (9.0655523e-05, 0.00026767772) (9.0391036e-05, 0.00026693853) (9.005537e-05, 0.00026622883) (8.9651757e-05, 0.00026555544) (8.9184084e-05, 0.00026492485) (8.8656854e-05, 0.00026434315) (8.8075146e-05, 0.00026381592) (8.7444562e-05, 0.00026334824) (8.6771174e-05, 0.00026294463) (8.6061467e-05, 0.00026260896) (8.5322277e-05, 0.00026234448) (8.4560723e-05, 0.00026215372) (8.3784137e-05, 0.00026203852) (8.3e-05, 0.000262) (-8.3e-05, 0.000262) (-8.3784137e-05, 0.00026203852) (-8.4560723e-05, 0.00026215372) (-8.5322277e-05, 0.00026234448) (-8.6061467e-05, 0.00026260896) (-8.6771174e-05, 0.00026294463) (-8.7444562e-05, 0.00026334824) (-8.8075146e-05, 0.00026381592) (-8.8656854e-05, 0.00026434315) (-8.9184084e-05, 0.00026492485) (-8.9651757e-05, 0.00026555544) (-9.005537e-05, 0.00026622883) (-9.0391036e-05, 0.00026693853) (-9.0655523e-05, 0.00026767772) (-9.0846282e-05, 0.00026843928) (-9.0961478e-05, 0.00026921586) (-9.1e-05, 0.00027) (-9.1e-05, 0.000295) (-9.0961478e-05, 0.00029578414) (-9.0846282e-05, 0.00029656072) (-9.0655523e-05, 0.00029732228) (-9.0391036e-05, 0.00029806147) (-9.005537e-05, 0.00029877117) (-8.9651757e-05, 0.00029944456) (-8.9184084e-05, 0.00030007515) (-8.8656854e-05, 0.00030065685) (-8.8075146e-05, 0.00030118408) (-8.7444562e-05, 0.00030165176) (-8.6771174e-05, 0.00030205537) (-8.6061467e-05, 0.00030239104) (-8.5322277e-05, 0.00030265552) (-8.4560723e-05, 0.00030284628) (-8.3784137e-05, 0.00030296148) (-8.3e-05, 0.000303) (8.3e-05, 0.000303) (8.3784137e-05, 0.00030296148) (8.4560723e-05, 0.00030284628) (8.5322277e-05, 0.00030265552) (8.6061467e-05, 0.00030239104) (8.6771174e-05, 0.00030205537) (8.7444562e-05, 0.00030165176) (8.8075146e-05, 0.00030118408) (8.8656854e-05, 0.00030065685) (8.9184084e-05, 0.00030007515) (8.9651757e-05, 0.00029944456) (9.005537e-05, 0.00029877117) (9.0391036e-05, 0.00029806147) (9.0655523e-05, 0.00029732228) (9.0846282e-05, 0.00029656072) (9.0961478e-05, 0.00029578414) (9.1e-05, 0.000295) (9.1e-05, 0.00027), closed, covered)
  frame_cp = polyline(z=0, xy: (9.5e-05, 0.00025) (9.5784137e-05, 0.00025003852) (9.6560723e-05, 0.00025015372) (9.7322277e-05, 0.00025034448) (9.8061467e-05, 0.00025060896) (9.8771174e-05, 0.00025094463) (9.9444562e-05, 0.00025134824) (0.00010007515, 0.00025181592) (0.00010065685, 0.00025234315) (0.00010118408, 0.00025292485) (0.00010165176, 0.00025355544) (0.00010205537, 0.00025422883) (0.00010239104, 0.00025493853) (0.00010265552, 0.00025567772) (0.00010284628, 0.00025643928) (0.00010296148, 0.00025721586) (0.000103, 0.000258) (0.000103, 0.000307) (0.00010296148, 0.00030778414) (0.00010284628, 0.00030856072) (0.00010265552, 0.00030932228) (0.00010239104, 0.00031006147) (0.00010205537, 0.00031077117) (0.00010165176, 0.00031144456) (0.00010118408, 0.00031207515) (0.00010065685, 0.00031265685) (0.00010007515, 0.00031318408) (9.9444562e-05, 0.00031365176) (9.8771174e-05, 0.00031405537) (9.8061467e-05, 0.00031439104) (9.7322277e-05, 0.00031465552) (9.6560723e-05, 0.00031484628) (9.5784137e-05, 0.00031496148) (9.5e-05, 0.000315) (2.509818e-05, 0.000315) (2.4901939e-05, 0.00031500482) (2.4412015e-05, 0.00031502889) (2.40216e-05, 0.00031506734) (2.3633541e-05, 0.0003151249) (2.3248774e-05, 0.00031520144) (2.2868226e-05, 0.00031529676) (2.2492814e-05, 0.00031541064) (2.2123441e-05, 0.0003155428) (2.1760999e-05, 0.00031569293) (2.140636e-05, 0.00031586066) (2.1060378e-05, 0.00031604559) (2.0723887e-05, 0.00031624728) (2.0397697e-05, 0.00031646523) (2.0082595e-05, 0.00031669893) (1.9779339e-05, 0.0003169478) (1.948866e-05, 0.00031721126) (1.9211259e-05, 0.00031748866) (1.8947803e-05, 0.00031777934) (1.8698928e-05, 0.00031808259) (1.8465232e-05, 0.0003183977) (1.8247279e-05, 0.00031872389) (1.8045594e-05, 0.00031906038) (1.7860663e-05, 0.00031940636) (1.7692931e-05, 0.000319761) (1.7542802e-05, 0.00032012344) (1.7410639e-05, 0.00032049281) (1.7296759e-05, 0.00032086823) (1.7201436e-05, 0.00032124877) (1.7124902e-05, 0.00032163354) (1.7067338e-05, 0.0003220216) (1.7028886e-05, 0.00032241201) (1.7004817e-05, 0.00032290194) (1.7e-05, 0.00032309818) (1.7e-05, 0.00036690182) (1.7004817e-05, 0.00036709806) (1.7028886e-05, 0.00036758799) (1.7067338e-05, 0.0003679784) (1.7124902e-05, 0.00036836646) (1.7201436e-05, 0.00036875123) (1.7296759e-05, 0.00036913177) (1.7410639e-05, 0.00036950719) (1.7542802e-05, 0.00036987656) (1.7692931e-05, 0.000370239) (1.7860663e-05, 0.00037059364) (1.8045594e-05, 0.00037093962) (1.8247279e-05, 0.00037127611) (1.8465232e-05, 0.0003716023) (1.8698928e-05, 0.0003719174) (1.8947803e-05, 0.00037222066) (1.9211259e-05, 0.00037251134) (1.948866e-05, 0.00037278874) (1.9779339e-05, 0.0003730522) (2.0082595e-05, 0.00037330107) (2.0397697e-05, 0.00037353477) (2.0723887e-05, 0.00037375272) (2.1060378e-05, 0.00037395441) (2.140636e-05, 0.00037413934) (2.1760999e-05, 0.00037430707) (2.2123441e-05, 0.0003744572) (2.2492814e-05, 0.00037458936) (2.2868226e-05, 0.00037470324) (2.3248774e-05, 0.00037479856) (2.3633541e-05, 0.0003748751) (2.40216e-05, 0.00037493266) (2.4412015e-05, 0.00037497111) (2.4901939e-05, 0.00037499518) (2.509818e-05, 0.000375) (0.00015190182, 0.000375) (0.00015209806, 0.00037499518) (0.00015258799, 0.00037497111) (0.0001529784, 0.00037493266) (0.00015336646, 0.0003748751) (0.00015375123, 0.00037479856) (0.00015413177, 0.00037470324) (0.00015450719, 0.00037458936) (0.00015487656, 0.0003744572) (0.000155239, 0.00037430707) (0.00015559364, 0.00037413934) (0.00015593962, 0.00037395441) (0.00015627611, 0.00037375272) (0.0001566023, 0.00037353477) (0.0001569174, 0.00037330107) (0.00015722066, 0.0003730522) (0.00015751134, 0.00037278874) (0.00015778874, 0.00037251134) (0.0001580522, 0.00037222066) (0.00015830107, 0.0003719174) (0.00015853477, 0.0003716023) (0.00015875272, 0.00037127611) (0.00015895441, 0.00037093962) (0.00015913934, 0.00037059364) (0.00015930707, 0.000370239) (0.0001594572, 0.00036987656) (0.00015958936, 0.00036950719) (0.00015970324, 0.00036913177) (0.00015979856, 0.00036875123) (0.0001598751, 0.00036836646) (0.00015993266, 0.0003679784) (0.00015997111, 0.00036758799) (0.00015999518, 0.00036709806) (0.00016, 0.00036690182) (0.00016, 0.00020609818) (0.00015999518, 0.00020590194) (0.00015997111, 0.00020541201) (0.00015993266, 0.0002050216) (0.0001598751, 0.00020463354) (0.00015979856, 0.00020424877) (0.00015970324, 0.00020386823) (0.00015958936, 0.00020349281) (0.0001594572, 0.00020312344) (0.00015930707, 0.000202761) (0.00015913934, 0.00020240636) (0.00015895441, 0.00020206038) (0.00015875272, 0.00020172389) (0.00015853477, 0.0002013977) (0.00015830107, 0.0002010826) (0.0001580522, 0.00020077934) (0.00015778874, 0.00020048866) (0.00015751134, 0.00020021126) (0.00015722066, 0.0001999478) (0.0001569174, 0.00019969893) (0.0001566023, 0.00019946523) (0.00015627611, 0.00019924728) (0.00015593962, 0.00019904559) (0.00015559364, 0.00019886066) (0.000155239, 0.00019869293) (0.00015487656, 0.0001985428) (0.00015450719, 0.00019841064) (0.00015413177, 0.00019829676) (0.00015375123, 0.00019820144) (0.00015336646, 0.0001981249) (0.0001529784, 0.00019806734) (0.00015258799, 0.00019802889) (0.00015209806, 0.00019800482) (0.00015190182, 0.000198) (-0.00015190182, 0.000198) (-0.00015209806, 0.00019800482) (-0.00015258799, 0.00019802889) (-0.0001529784, 0.00019806734) (-0.00015336646, 0.0001981249) (-0.00015375123, 0.00019820144) (-0.00015413177, 0.00019829676) (-0.00015450719, 0.00019841064) (-0.00015487656, 0.0001985428) (-0.000155239, 0.00019869293) (-0.00015559364, 0.00019886066) (-0.00015593962, 0.00019904559) (-0.00015627611, 0.00019924728) (-0.0001566023, 0.00019946523) (-0.0001569174, 0.00019969893) (-0.00015722066, 0.0001999478) (-0.00015751134, 0.00020021126) (-0.00015778874, 0.00020048866) (-0.0001580522, 0.00020077934) (-0.00015830107, 0.0002010826) (-0.00015853477, 0.0002013977) (-0.00015875272, 0.00020172389) (-0.00015895441, 0.00020206038) (-0.00015913934, 0.00020240636) (-0.00015930707, 0.000202761) (-0.0001594572, 0.00020312344) (-0.00015958936, 0.00020349281) (-0.00015970324, 0.00020386823) (-0.00015979856, 0.00020424877) (-0.0001598751, 0.00020463354) (-0.00015993266, 0.0002050216) (-0.00015997111, 0.00020541201) (-0.00015999518, 0.00020590194) (-0.00016, 0.00020609818) (-0.00016, 0.00036690182) (-0.00015999518, 0.00036709806) (-0.00015997111, 0.00036758799) (-0.00015993266, 0.0003679784) (-0.0001598751, 0.00036836646) (-0.00015979856, 0.00036875123) (-0.00015970324, 0.00036913177) (-0.00015958936, 0.00036950719) (-0.0001594572, 0.00036987656) (-0.00015930707, 0.000370239) (-0.00015913934, 0.00037059364) (-0.00015895441, 0.00037093962) (-0.00015875272, 0.00037127611) (-0.00015853477, 0.0003716023) (-0.00015830107, 0.0003719174) (-0.0001580522, 0.00037222066) (-0.00015778874, 0.00037251134) (-0.00015751134, 0.00037278874) (-0.00015722066, 0.0003730522) (-0.0001569174, 0.00037330107) (-0.0001566023, 0.00037353477) (-0.00015627611, 0.00037375272) (-0.00015593962, 0.00037395441) (-0.00015559364, 0.00037413934) (-0.000155239, 0.00037430707) (-0.00015487656, 0.0003744572) (-0.00015450719, 0.00037458936) (-0.00015413177, 0.00037470324) (-0.00015375123, 0.00037479856) (-0.00015336646, 0.0003748751) (-0.0001529784, 0.00037493266) (-0.00015258799, 0.00037497111) (-0.00015209806, 0.00037499518) (-0.00015190182, 0.000375) (-2.509818e-05, 0.000375) (-2.4901939e-05, 0.00037499518) (-2.4412015e-05, 0.00037497111) (-2.40216e-05, 0.00037493266) (-2.3633541e-05, 0.0003748751) (-2.3248774e-05, 0.00037479856) (-2.2868226e-05, 0.00037470324) (-2.2492814e-05, 0.00037458936) (-2.2123441e-05, 0.0003744572) (-2.1760999e-05, 0.00037430707) (-2.140636e-05, 0.00037413934) (-2.1060378e-05, 0.00037395441) (-2.0723887e-05, 0.00037375272) (-2.0397697e-05, 0.00037353477) (-2.0082595e-05, 0.00037330107) (-1.9779339e-05, 0.0003730522) (-1.948866e-05, 0.00037278874) (-1.9211259e-05, 0.00037251134) (-1.8947803e-05, 0.00037222066) (-1.8698928e-05, 0.0003719174) (-1.8465232e-05, 0.0003716023) (-1.8247279e-05, 0.00037127611) (-1.8045594e-05, 0.00037093962) (-1.7860663e-05, 0.00037059364) (-1.7692931e-05, 0.000370239) (-1.7542802e-05, 0.00036987656) (-1.7410639e-05, 0.00036950719) (-1.7296759e-05, 0.00036913177) (-1.7201436e-05, 0.00036875123) (-1.7124902e-05, 0.00036836646) (-1.7067338e-05, 0.0003679784) (-1.7028886e-05, 0.00036758799) (-1.7004817e-05, 0.00036709806) (-1.7e-05, 0.00036690182) (-1.7e-05, 0.00032309818) (-1.7004817e-05, 0.00032290194) (-1.7028886e-05, 0.00032241201) (-1.7067338e-05, 0.0003220216) (-1.7124902e-05, 0.00032163354) (-1.7201436e-05, 0.00032124877) (-1.7296759e-05, 0.00032086823) (-1.7410639e-05, 0.00032049281) (-1.7542802e-05, 0.00032012344) (-1.7692931e-05, 0.000319761) (-1.7860663e-05, 0.00031940636) (-1.8045594e-05, 0.00031906038) (-1.8247279e-05, 0.00031872389) (-1.8465232e-05, 0.0003183977) (-1.8698928e-05, 0.00031808259) (-1.8947803e-05, 0.00031777934) (-1.9211259e-05, 0.00031748866) (-1.948866e-05, 0.00031721126) (-1.9779339e-05, 0.0003169478) (-2.0082595e-05, 0.00031669893) (-2.0397697e-05, 0.00031646523) (-2.0723887e-05, 0.00031624728) (-2.1060378e-05, 0.00031604559) (-2.140636e-05, 0.00031586066) (-2.1760999e-05, 0.00031569293) (-2.2123441e-05, 0.0003155428) (-2.2492814e-05, 0.00031541064) (-2.2868226e-05, 0.00031529676)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, closed, covered)
  pocket_cp = polyline(z=0, xy: (0.00016, 0.000186) (-0.00016, 0.000186) (-0.00016117621, 0.00018605778) (-0.00016234108, 0.00018623058) (-0.00016348342, 0.00018651672) (-0.0001645922, 0.00018691345) (-0.00016565676, 0.00018741695) (-0.00016666684, 0.00018802236) (-0.00016761272, 0.00018872387) (-0.00016848528, 0.00018951472) (-0.00016927613, 0.00019038728) (-0.00016997764, 0.00019133316) (-0.00017058306, 0.00019234324) (-0.00017108655, 0.0001934078) (-0.00017148328, 0.00019451658) (-0.00017176942, 0.00019565892) (-0.00017194222, 0.00019682379) (-0.000172, 0.000198) (-0.000172, 0.000375) (-0.00017194222, 0.00037617621) (-0.00017176942, 0.00037734108) (-0.00017148328, 0.00037848342) (-0.00017108655, 0.0003795922) (-0.00017058306, 0.00038065676) (-0.00016997764, 0.00038166684) (-0.00016927613, 0.00038261272) (-0.00016848528, 0.00038348528) (-0.00016761272, 0.00038427613) (-0.00016666684, 0.00038497764) (-0.00016565676, 0.00038558305) (-0.0001645922, 0.00038608655) (-0.00016348342, 0.00038648328) (-0.00016234108, 0.00038676942) (-0.00016117621, 0.00038694222) (-0.00016, 0.000387) (0.00016, 0.000387) (0.00016117621, 0.00038694222) (0.00016234108, 0.00038676942) (0.00016348342, 0.00038648328) (0.0001645922, 0.00038608655) (0.00016565676, 0.00038558305) (0.00016666684, 0.00038497764) (0.00016761272, 0.00038427613) (0.00016848528, 0.00038348528) (0.00016927613, 0.00038261272) (0.00016997764, 0.00038166684) (0.00017058306, 0.00038065676) (0.00017108655, 0.0003795922) (0.00017148328, 0.00037848342) (0.00017176942, 0.00037734108) (0.00017194222, 0.00037617621) (0.000172, 0.000375) (0.000172, 0.000198) (0.00017194222, 0.00019682379) (0.00017176942, 0.00019565892) (0.00017148328, 0.00019451658) (0.00017108655, 0.0001934078) (0.00017058306, 0.00019234324) (0.00016997764, 0.00019133316) (0.00016927613, 0.00019038728) (0.00016848528, 0.00018951472) (0.00016761272, 0.00018872387) (0.00016666684, 0.00018802236) (0.00016565676, 0.00018741695) (0.0001645922, 0.00018691345) (0.00016348342, 0.00018651672) (0.00016234108, 0.00018623058) (0.00016117621, 0.00018605778) (0.00016, 0.000186), closed, covered)
  tap_trace_jf = polyline(z=0, xy: (-8e-06, 0.001465) (-8e-06, 0.001765) (8e-06, 0.001765) (8e-06, 0.001623) (0.000124, 0.001623) (0.000124, 0.001607) (8e-06, 0.001607) (8e-06, 0.001465) (-8e-06, 0.001465), closed, covered)
  tap_cut_jf = polyline(z=0, xy: (-1.7e-05, 0.001465) (-1.7e-05, 0.001765) (1.7e-05, 0.001765) (1.7e-05, 0.001632) (0.000124, 0.001632) (0.000124, 0.001598) (1.7e-05, 0.001598) (1.7e-05, 0.001465) (-1.7e-05, 0.001465), closed, covered)
  tap_trace_jr = polyline(z=0, xy: (0.000276, 0.001623) (0.000392, 0.001623) (0.000392, 0.001765) (0.000408, 0.001765) (0.000408, 0.001465) (0.000392, 0.001465) (0.000392, 0.001607) (0.000276, 0.001607) (0.000276, 0.001623), closed, covered)
  tap_cut_jr = polyline(z=0, xy: (0.000276, 0.001632) (0.000383, 0.001632) (0.000383, 0.001765) (0.000417, 0.001765) (0.000417, 0.001465) (0.000383, 0.001465) (0.000383, 0.001598) (0.000276, 0.001598) (0.000276, 0.001632), closed, covered)
  head_a_cj = polyline(z=0, xy: (0.000156, 0.0015825) (0.00015580397, 0.0015825096) (0.00015560982, 0.0015825384) (0.00015541943, 0.0015825861) (0.00015523463, 0.0015826522) (0.00015505721, 0.0015827362) (0.00015488886, 0.0015828371) (0.00015473121, 0.001582954) (0.00015458579, 0.0015830858) (0.00015445398, 0.0015832312) (0.00015433706, 0.0015833889) (0.00015423616, 0.0015835572) (0.00015415224, 0.0015837346) (0.00015408612, 0.0015839194) (0.00015403843, 0.0015841098) (0.00015400963, 0.001584304) (0.000154, 0.0015845) (0.000154, 0.0016455) (0.00015400963, 0.001645696) (0.00015403843, 0.0016458902) (0.00015408612, 0.0016460806) (0.00015415224, 0.0016462654) (0.00015423616, 0.0016464428) (0.00015433706, 0.0016466111) (0.00015445398, 0.0016467688) (0.00015458579, 0.0016469142) (0.00015473121, 0.001647046) (0.00015488886, 0.0016471629) (0.00015505721, 0.0016472638) (0.00015523463, 0.0016473478) (0.00015541943, 0.0016474139) (0.00015560982, 0.0016474616) (0.00015580397, 0.0016474904) (0.000156, 0.0016475) (0.000177, 0.0016475) (0.00017719603, 0.0016474904) (0.00017739018, 0.0016474616) (0.00017758057, 0.0016474139) (0.00017776537, 0.0016473478) (0.00017794279, 0.0016472638) (0.00017811114, 0.0016471629) (0.00017826879, 0.001647046) (0.00017841421, 0.0016469142) (0.00017854602, 0.0016467688) (0.00017866294, 0.0016466111) (0.00017876384, 0.0016464428) (0.00017884776, 0.0016462654) (0.00017891388, 0.0016460806) (0.00017896157, 0.0016458902) (0.00017899037, 0.001645696) (0.000179, 0.0016455) (0.000179, 0.0015845) (0.00017899037, 0.001584304) (0.00017896157, 0.0015841098) (0.00017891388, 0.0015839194) (0.00017884776, 0.0015837346) (0.00017876384, 0.0015835572) (0.00017866294, 0.0015833889) (0.00017854602, 0.0015832312) (0.00017841421, 0.0015830858) (0.00017826879, 0.001582954) (0.00017811114, 0.0015828371) (0.00017794279, 0.0015827362) (0.00017776537, 0.0015826522) (0.00017758057, 0.0015825861) (0.00017739018, 0.0015825384) (0.00017719603, 0.0015825096) (0.000177, 0.0015825) (0.000156, 0.0015825), closed, covered)
  head_b_cj = polyline(z=0, xy: (0.000223, 0.0015825) (0.00022280397, 0.0015825096) (0.00022260982, 0.0015825384) (0.00022241943, 0.0015825861) (0.00022223463, 0.0015826522) (0.00022205721, 0.0015827362) (0.00022188886, 0.0015828371) (0.00022173121, 0.001582954) (0.00022158579, 0.0015830858) (0.00022145398, 0.0015832312) (0.00022133706, 0.0015833889) (0.00022123616, 0.0015835572) (0.00022115224, 0.0015837346) (0.00022108612, 0.0015839194) (0.00022103843, 0.0015841098) (0.00022100963, 0.001584304) (0.000221, 0.0015845) (0.000221, 0.0016455) (0.00022100963, 0.001645696) (0.00022103843, 0.0016458902) (0.00022108612, 0.0016460806) (0.00022115224, 0.0016462654) (0.00022123616, 0.0016464428) (0.00022133706, 0.0016466111) (0.00022145398, 0.0016467688) (0.00022158579, 0.0016469142) (0.00022173121, 0.001647046) (0.00022188886, 0.0016471629) (0.00022205721, 0.0016472638) (0.00022223463, 0.0016473478) (0.00022241943, 0.0016474139) (0.00022260982, 0.0016474616) (0.00022280397, 0.0016474904) (0.000223, 0.0016475) (0.000244, 0.0016475) (0.00024419603, 0.0016474904) (0.00024439018, 0.0016474616) (0.00024458057, 0.0016474139) (0.00024476537, 0.0016473478) (0.00024494279, 0.0016472638) (0.00024511114, 0.0016471629) (0.00024526879, 0.001647046) (0.00024541421, 0.0016469142) (0.00024554602, 0.0016467688) (0.00024566294, 0.0016466111) (0.00024576384, 0.0016464428) (0.00024584776, 0.0016462654) (0.00024591388, 0.0016460806) (0.00024596157, 0.0016458902) (0.00024599037, 0.001645696) (0.000246, 0.0016455) (0.000246, 0.0015845) (0.00024599037, 0.001584304) (0.00024596157, 0.0015841098) (0.00024591388, 0.0015839194) (0.00024584776, 0.0015837346) (0.00024576384, 0.0015835572) (0.00024566294, 0.0015833889) (0.00024554602, 0.0015832312) (0.00024541421, 0.0015830858) (0.00024526879, 0.001582954) (0.00024511114, 0.0015828371) (0.00024494279, 0.0015827362) (0.00024476537, 0.0015826522) (0.00024458057, 0.0015825861) (0.00024439018, 0.0015825384) (0.00024419603, 0.0015825096) (0.000244, 0.0015825) (0.000223, 0.0015825), closed, covered)
  pocket_cj = polyline(z=0, xy: (0.00014, 0.0015665) (0.00013980397, 0.0015665096) (0.00013960982, 0.0015665384) (0.00013941943, 0.0015665861) (0.00013923463, 0.0015666522) (0.00013905721, 0.0015667362) (0.00013888886, 0.0015668371) (0.00013873121, 0.001566954) (0.00013858579, 0.0015670858) (0.00013845398, 0.0015672312) (0.00013833706, 0.0015673889) (0.00013823616, 0.0015675572) (0.00013815224, 0.0015677346) (0.00013808612, 0.0015679194) (0.00013803843, 0.0015681098) (0.00013800963, 0.001568304) (0.000138, 0.0015685) (0.000138, 0.0016615) (0.00013800963, 0.001661696) (0.00013803843, 0.0016618902) (0.00013808612, 0.0016620806) (0.00013815224, 0.0016622654) (0.00013823616, 0.0016624428) (0.00013833706, 0.0016626111) (0.00013845398, 0.0016627688) (0.00013858579, 0.0016629142) (0.00013873121, 0.001663046) (0.00013888886, 0.0016631629) (0.00013905721, 0.0016632638) (0.00013923463, 0.0016633478) (0.00013941943, 0.0016634139) (0.00013960982, 0.0016634616) (0.00013980397, 0.0016634904) (0.00014, 0.0016635) (0.00026, 0.0016635) (0.00026019603, 0.0016634904) (0.00026039018, 0.0016634616) (0.00026058057, 0.0016634139) (0.00026076537, 0.0016633478) (0.00026094279, 0.0016632638) (0.00026111114, 0.0016631629) (0.00026126879, 0.001663046) (0.00026141421, 0.0016629142) (0.00026154602, 0.0016627688) (0.00026166294, 0.0016626111) (0.00026176384, 0.0016624428) (0.00026184776, 0.0016622654) (0.00026191388, 0.0016620806) (0.00026196157, 0.0016618902) (0.00026199037, 0.001661696) (0.000262, 0.0016615) (0.000262, 0.0015685) (0.00026199037, 0.001568304) (0.00026196157, 0.0015681098) (0.00026191388, 0.0015679194) (0.00026184776, 0.0015677346) (0.00026176384, 0.0015675572) (0.00026166294, 0.0015673889) (0.00026154602, 0.0015672312) (0.00026141421, 0.0015670858) (0.00026126879, 0.001566954) (0.00026111114, 0.0015668371) (0.00026094279, 0.0015667362) (0.00026076537, 0.0015666522) (0.00026058057, 0.0015665861) (0.00026039018, 0.0015665384) (0.00026019603, 0.0015665096) (0.00026, 0.0015665) (0.00014, 0.0015665), closed, covered)
  open_to_ground_readout_open = rectangle(corner=(0.000383, 0.002915, 0), x_size=3.4e-05, y_size=6e-06)
  endcap_feed_in_start = rectangle(corner=(-0.0016296, -1.76e-05, 0), x_size=9.6e-06, y_size=3.52e-05)
  endcap_feed_out_end = rectangle(corner=(0.00162, -1.76e-05, 0), x_size=9.6e-06, y_size=3.52e-05)
  ground_main_plane = rectangle(corner=(-0.00182, -0.000372, 0), x_size=0.00364, y_size=0.0034945638)
  main [silicon_eps11p5] = box(corner=(-0.00182, -0.000372, -0.0005), size=(0.00364, 0.0034945638, 0.0005))
  sample_holder [vacuum] = box(corner=(-0.00182, -0.000372, -0.00165), size=(0.00364, 0.0034945638, 0.00254))
  ground_main_plane.subtract(cut_feed_jf, lead_b_sub_cin, cut_filter_tail, lead_a_sub_cp, cut_stub_f, lead_b_sub_cj, lead_a_sub_cj, open_to_ground_readout_open, cut_stub_p, lead_b_sub_cp, cut_res_open_run, endcap_feed_out_end, cut_feed_in, pocket_cp, pocket_cj, tap_cut_jr, cut_stub_r, pocket_cin, cut_feed_mid, cut_res_tail, tap_cut_n0, endcap_feed_in_start, tap_cut_jf, cut_feed_out, lead_a_sub_cin)
  Port_feed_in_start = rectangle(corner=(-0.0016296, -8e-06, 0), x_size=9.6e-06, y_size=1.6e-05)
  voltage_line_Port_feed_in_start = polyline((-0.00162, 0, 0) (-0.0016296, 0, 0))
  Port_feed_out_end = rectangle(corner=(0.00162, -8e-06, 0), x_size=9.6e-06, y_size=1.6e-05)
  voltage_line_Port_feed_out_end = polyline((0.00162, 0, 0) (0.0016296, 0, 0))
  g_wb_30 [pec] = bondwire(WireType=LOW WireDiameter=0.015mm NumSides=6 XPadPos=7.75e-05 YPadPos=0.001585 ZPadPos=0 XDir=0 YDir=1 ZDir=0 Distance=6e-05 h1=6e-05 h2=0mm alpha=80deg beta=80deg WhichAxis=Z)
  g_wb_31 [pec] = bondwire(WireType=LOW WireDiameter=0.015mm NumSides=6 XPadPos=0.0003225 YPadPos=0.001585 ZPadPos=0 XDir=0 YDir=1 ZDir=0 Distance=6e-05 h1=6e-05 h2=0mm alpha=80deg beta=80deg WhichAxis=Z)
  g_wb_32 [pec] = bondwire(WireType=LOW WireDiameter=0.015mm NumSides=6 XPadPos=-3.65e-05 YPadPos=3e-05 ZPadPos=0 XDir=0 YDir=-1 ZDir=0 Distance=6e-05 h1=6e-05 h2=0mm alpha=80deg beta=80deg WhichAxis=Z)
  g_wb_33 [pec] = bondwire(WireType=LOW WireDiameter=0.015mm NumSides=6 XPadPos=3.65e-05 YPadPos=-3e-05 ZPadPos=0 XDir=0 YDir=1 ZDir=0 Distance=6e-05 h1=6e-05 h2=0mm alpha=80deg beta=80deg WhichAxis=Z)
  g_wb_34 [pec] = bondwire(WireType=LOW WireDiameter=0.015mm NumSides=6 XPadPos=3e-05 YPadPos=6.45e-05 ZPadPos=0 XDir=-1 YDir=0 ZDir=0 Distance=6e-05 h1=6e-05 h2=0mm alpha=80deg beta=80deg WhichAxis=Z)
  g_wb_35 [pec] = bondwire(WireType=LOW WireDiameter=0.015mm NumSides=6 XPadPos=3e-05 YPadPos=0.0016515 ZPadPos=0 XDir=-1 YDir=0 ZDir=0 Distance=6e-05 h1=6e-05 h2=0mm alpha=80deg beta=80deg WhichAxis=Z)
  g_wb_36 [pec] = bondwire(WireType=LOW WireDiameter=0.015mm NumSides=6 XPadPos=-3e-05 YPadPos=0.0015785 ZPadPos=0 XDir=1 YDir=0 ZDir=0 Distance=6e-05 h1=6e-05 h2=0mm alpha=80deg beta=80deg WhichAxis=Z)
  g_wb_37 [pec] = bondwire(WireType=LOW WireDiameter=0.015mm NumSides=6 XPadPos=0.00043 YPadPos=0.0016515 ZPadPos=0 XDir=-1 YDir=0 ZDir=0 Distance=6e-05 h1=6e-05 h2=0mm alpha=80deg beta=80deg WhichAxis=Z)
  g_wb_38 [pec] = bondwire(WireType=LOW WireDiameter=0.015mm NumSides=6 XPadPos=0.00037 YPadPos=0.0015785 ZPadPos=0 XDir=1 YDir=0 ZDir=0 Distance=6e-05 h1=6e-05 h2=0mm alpha=80deg beta=80deg WhichAxis=Z)
boundaries and excitations:
  RLCBoundary_feed_in_start: Lumped RLC Objects=Port_feed_in_start CurrentLine{middle of Port_feed_in_start.edge(x at corner) -> middle of Port_feed_in_start.edge(x opposite corner)} RLC_Type=Parallel Resistance=50ohm
  RLCBoundary_feed_out_end: Lumped RLC Objects=Port_feed_out_end CurrentLine{middle of Port_feed_out_end.edge(x at corner) -> middle of Port_feed_out_end.edge(x opposite corner)} RLC_Type=Parallel Resistance=50ohm
  PerfE: Perfect E Objects=[lead_a_cin, lead_b_cin, lead_a_cp, lead_b_cp, trace_feed_in, trace_feed_mid, trace_feed_out, trace_stub_p, lead_a_cj, lead_b_cj, trace_stub_f, trace_stub_r, trace_feed_jf, trace_res_open_run, trace_filter_tail, trace_res_tail, plate_cin, frame_cin, tap_trace_n0, plate_cp, frame_cp, tap_trace_jf, tap_trace_jr, head_a_cj, head_b_cj, ground_main_plane]
mesh:
  port_mesh: LengthBased Objects=[Port_feed_in_start, Port_feed_out_end] MaxLength=7um
  cpw_line_mesh: LengthBased Objects=[lead_a_cin, lead_b_cin, trace_feed_in, trace_feed_mid, trace_feed_out, trace_stub_p, trace_stub_f, trace_stub_r, trace_feed_jf, trace_res_open_run, trace_filter_tail, trace_res_tail, plate_cin, frame_cin, tap_trace_n0, tap_trace_jf, tap_trace_jr] MaxLength=10um
  cap_mesh: LengthBased Objects=[lead_a_cp, lead_b_cp, lead_a_cj, lead_b_cj, plate_cp, frame_cp, head_a_cj, head_b_cj] MaxLength=10um
setups:
  Setup: HfssEigen MinimumFrequency=5.8GHz NumModes=2 MaxDeltaFreq=0.1 ConvergeOnRealFreq=true MaximumPasses=6 MinimumPasses=3 MinimumConvergedPasses=2 PercentRefinement=20 BasisOrder=1
source amplitudes:
  #-10:1: 1 0deg
  #-10:2: 0 0deg
reports:
  Eigen Modes Plot 1: re(Mode(1)), re(Mode(2)) vs Pass on Setup : AdaptivePass
  Freq. vs. pass: re(Mode(1)), re(Mode(2)) vs Pass on Setup : AdaptivePass
